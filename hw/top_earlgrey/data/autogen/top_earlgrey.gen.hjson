// Copyright lowRISC contributors (OpenTitan project).
// Licensed under the Apache License, Version 2.0, see LICENSE for details.
// SPDX-License-Identifier: Apache-2.0
//
// ------------------- W A R N I N G: A U T O - G E N E R A T E D   C O D E !! -------------------//
// PLEASE DO NOT HAND-EDIT THIS FILE. IT HAS BEEN AUTO-GENERATED WITH THE FOLLOWING COMMAND:
// util/topgen.py -t hw/top_earlgrey/data/top_earlgrey.hjson
//                -o hw/top_earlgrey/
{
  name: earlgrey
  type: top
  datawidth: "32"
  power:
  {
    domains:
    [
      Aon
      Main
    ]
    default: Main
    wait_for_external_reset: false
  }
  unmanaged_clocks:
  {
    ast_ext:
    {
      name: ast_ext
      signal_name: clk_ast_ext_i
      cg_en_signal: cg_en_ast_ext_i
    }
  }
  clocks:
  {
    srcs:
    [
      {
        name: main
        aon: no
        freq: "100000000"
        ref: false
        module: ast
        signal: clk_src_sys
        partition: primary
      }
      {
        name: io
        aon: no
        freq: "96000000"
        ref: false
        module: ast
        signal: clk_src_io
        partition: primary
      }
      {
        name: usb
        aon: no
        freq: "48000000"
        ref: false
        module: ast
        signal: clk_src_usb
        partition: primary
      }
      {
        name: aon
        aon: yes
        freq: "200000"
        ref: true
        module: ast
        signal: clk_src_aon
        partition: secondary
      }
    ]
    derived_srcs:
    [
      {
        name: io_div4
        aon: no
        freq: "24000000"
        ref: false
        div: "4"
        src: io
      }
    ]
    groups:
    [
      {
        name: ast
        src: ext
        sw_cg: no
        unique: no
        clocks:
        {
          clk_main_i: main
          clk_io_i: io
          clk_usb_i: usb
          clk_aon_i: aon
        }
      }
      {
        name: powerup
        src: top
        sw_cg: no
        unique: no
        clocks:
        {
          clk_io_div4_powerup: io_div4
          clk_aon_powerup: aon
          clk_main_powerup: main
          clk_io_powerup: io
          clk_usb_powerup: usb
        }
      }
      {
        name: trans
        src: top
        sw_cg: hint
        unique: yes
        clocks:
        {
          clk_main_aes: main
          clk_main_hmac: main
          clk_main_kmac: main
          clk_main_otbn: main
        }
      }
      {
        name: infra
        src: top
        sw_cg: no
        unique: no
        clocks:
        {
          clk_io_div4_infra: io_div4
          clk_main_infra: main
          clk_usb_infra: usb
          clk_io_infra: io
        }
      }
      {
        name: secure
        src: top
        sw_cg: no
        unique: no
        clocks:
        {
          clk_io_div4_secure: io_div4
          clk_main_secure: main
          clk_aon_secure: aon
        }
      }
      {
        name: peri
        src: top
        sw_cg: yes
        unique: no
        clocks:
        {
          clk_io_div4_peri: io_div4
          clk_io_peri: io
          clk_aon_peri: aon
          clk_usb_peri: usb
        }
      }
      {
        name: spi_host1
        src: top
        sw_cg: yes
        unique: no
        clocks:
        {
          clk_io_spi_host1: io
        }
      }
      {
        name: timers
        src: top
        sw_cg: no
        unique: no
        clocks:
        {
          clk_io_div4_timers: io_div4
          clk_aon_timers: aon
        }
      }
    ]
  }
  resets:
  {
    nodes:
    [
      {
        name: por_aon
        gen: false
        type: top
        domains:
        [
          Main
          Aon
        ]
        shadowed: false
        sw: false
        path: rst_por_aon_n
        clock: aon
      }
      {
        name: lc_src
        gen: false
        type: int
        domains: []
        shadowed: false
        sw: false
        path: ""
        clock: io_div4
      }
      {
        name: sys_src
        gen: false
        type: int
        domains: []
        shadowed: false
        sw: false
        path: ""
        clock: io_div4
      }
      {
        name: por
        gen: true
        type: top
        domains:
        [
          Aon
        ]
        shadowed: false
        sw: false
        path: rst_por_n
        parent: por_aon
        clock: main
      }
      {
        name: por_io
        gen: true
        type: top
        domains:
        [
          Aon
        ]
        shadowed: false
        sw: false
        path: rst_por_io_n
        parent: por_aon
        clock: io
      }
      {
        name: por_io_div4
        gen: true
        type: top
        domains:
        [
          Aon
        ]
        shadowed: false
        sw: false
        path: rst_por_io_div4_n
        parent: por_aon
        clock: io_div4
      }
      {
        name: por_usb
        gen: true
        type: top
        domains:
        [
          Aon
        ]
        shadowed: false
        sw: false
        path: rst_por_usb_n
        parent: por_aon
        clock: usb
      }
      {
        name: lc
        gen: true
        type: top
        domains:
        [
          Main
          Aon
        ]
        shadowed: true
        sw: false
        path: rst_lc_n
        parent: lc_src
        clock: main
      }
      {
        name: lc_aon
        gen: true
        type: top
        domains:
        [
          Main
          Aon
        ]
        shadowed: false
        sw: false
        path: rst_lc_aon_n
        parent: lc_src
        clock: aon
      }
      {
        name: lc_io
        gen: true
        type: top
        domains:
        [
          Aon
          Main
        ]
        shadowed: false
        sw: false
        path: rst_lc_io_n
        parent: lc_src
        clock: io
      }
      {
        name: lc_io_div4
        gen: true
        type: top
        domains:
        [
          Main
          Aon
        ]
        shadowed: true
        sw: false
        path: rst_lc_io_div4_n
        parent: lc_src
        clock: io_div4
      }
      {
        name: lc_usb
        gen: true
        type: top
        domains:
        [
          Aon
          Main
        ]
        shadowed: false
        sw: false
        path: rst_lc_usb_n
        parent: lc_src
        clock: usb
      }
      {
        name: sys
        gen: true
        type: top
        domains:
        [
          Main
        ]
        shadowed: false
        sw: false
        path: rst_sys_n
        parent: sys_src
        clock: main
      }
      {
        name: sys_io_div4
        gen: true
        type: top
        domains:
        [
          Aon
        ]
        shadowed: false
        sw: false
        path: rst_sys_io_div4_n
        parent: sys_src
        clock: io_div4
      }
      {
        name: spi_device
        gen: true
        type: top
        domains:
        [
          Main
        ]
        shadowed: false
        sw: true
        path: rst_spi_device_n
        parent: lc_src
        clock: io_div4
      }
      {
        name: spi_host0
        gen: true
        type: top
        domains:
        [
          Main
        ]
        shadowed: false
        sw: true
        path: rst_spi_host0_n
        parent: lc_src
        clock: io
      }
      {
        name: spi_host1
        gen: true
        type: top
        domains:
        [
          Main
        ]
        shadowed: false
        sw: true
        path: rst_spi_host1_n
        parent: lc_src
        clock: io
      }
      {
        name: usb
        gen: true
        type: top
        domains:
        [
          Main
        ]
        shadowed: false
        sw: true
        path: rst_usb_n
        parent: lc_src
        clock: usb
      }
      {
        name: usb_aon
        gen: true
        type: top
        domains:
        [
          Main
        ]
        shadowed: false
        sw: true
        path: rst_usb_aon_n
        parent: lc_src
        clock: aon
      }
      {
        name: i2c0
        gen: true
        type: top
        domains:
        [
          Main
        ]
        shadowed: false
        sw: true
        path: rst_i2c0_n
        parent: lc_src
        clock: io_div4
      }
      {
        name: i2c1
        gen: true
        type: top
        domains:
        [
          Main
        ]
        shadowed: false
        sw: true
        path: rst_i2c1_n
        parent: lc_src
        clock: io_div4
      }
      {
        name: i2c2
        gen: true
        type: top
        domains:
        [
          Main
        ]
        shadowed: false
        sw: true
        path: rst_i2c2_n
        parent: lc_src
        clock: io_div4
      }
      {
        name: i3c0
        gen: true
        type: top
        domains:
        [
          Main
        ]
        shadowed: false
        sw: true
        path: rst_i3c0_n
        parent: lc_src
        clock: io
      }
      {
        name: i3c1
        gen: true
        type: top
        domains:
        [
          Main
        ]
        shadowed: false
        sw: true
        path: rst_i3c1_n
        parent: lc_src
        clock: io
      }
    ]
  }
  reset_requests:
  {
    int:
    [
      {
        name: MainPwr
        desc: main power glitch reset request
        module: pwrmgr
      }
      {
        name: Esc
        desc: escalation reset request
        module: alert_handler
      }
    ]
    debug:
    [
      {
        name: Ndm
        desc: non-debug-module reset request
        module: rv_dm
      }
    ]
    peripheral:
    [
      {
        name: rst_req
        width: "1"
        module: sysrst_ctrl
        desc: OpenTitan reset request to `rstmgr` (running on AON clock).
        enabled_after_reset: false
      }
      {
        name: aon_timer_rst_req
        width: "1"
        module: aon_timer
        desc: Watchdog reset request.
        enabled_after_reset: false
      }
    ]
  }
  num_cores: "1"
  default_plic: rv_plic
  default_alert_handler: alert_handler
  addr_spaces:
  [
    {
      name: hart
      desc: The main address space, shared between the CPU and DM
      subspaces:
      [
        {
          name: mmio
          desc:
            '''
            MMIO region excludes any memory that is separate from the module configuration
            space, i.e. ROM, main SRAM, and RRAM are excluded but retention SRAM, spi_device
            memory, or usbdev memory are included.
            '''
          nodes:
          [
            uart0
            uart1
            uart2
            uart3
            gpio0
            gpio1
            spi_device
            i2c0
            i2c1
            i2c2
            i3c0
            i3c1
            rv_timer
            otp_ctrl
            lc_ctrl.regs
            alert_handler
            spi_host0
            spi_host1
            usbdev
            pwrmgr
            rstmgr
            clkmgr
            sysrst_ctrl
            adc_ctrl
            pinmux
            aon_timer
            ast
            sensor_ctrl
            sram_ctrl_ret
            rram_ctrl.core
            rram_macro.prim
            rv_plic
            aes
            hmac
            kmac
            otbn
            keymgr_dpe
            csrng
            entropy_src
            edn0
            edn1
            sram_ctrl_main.regs
            sram_ctrl_sec.regs
            sram_ctrl_meta.regs
            rom_ctrl.regs
            rv_core_ibex
            cheriot_mem_sys.regs
          ]
        }
      ]
    }
  ]
  module:
  [
    {
      name: uart0
      type: uart
      clock_srcs:
      {
        clk_i: io_div4
      }
      clock_group: peri
      reset_connections:
      {
        rst_ni:
        {
          name: lc_io_div4
          domain: Main
        }
      }
      domain: Main
      clock_connections:
      {
        clk_i: clkmgr_clocks_i.clk_io_div4_peri
      }
      param_decl: {}
      memory: {}
      param_list: []
      inter_signal_list:
      [
        {
          name: lsio_trigger
          desc:
            '''
            Self-clearing status trigger for the DMA.
            Set when RX or TX FIFOs are past their configured watermarks matching watermark interrupt behaviour.
            '''
          struct: logic
          type: uni
          act: req
          width: 1
          inst_name: uart0
          index: -1
        }
        {
          name: racl_policies
          desc:
            '''
            Incoming RACL policy vector from a racl_ctrl instance.
            The policy selection vector (parameter) selects the policy for each register.
            '''
          struct: racl_policy_vec
          package: top_racl_pkg
          type: uni
          act: rcv
          width: 1
          inst_name: uart0
          index: -1
        }
        {
          name: racl_error
          desc: RACL error log information of this module.
          struct: racl_error_log
          package: top_racl_pkg
          type: uni
          act: req
          width: 1
          inst_name: uart0
          index: -1
        }
        {
          name: tl
          struct: tl
          package: tlul_pkg
          type: req_rsp
          act: rsp
          width: 1
          inst_name: uart0
          default: ""
          end_idx: -1
          top_type: one-to-one
          top_signame: uart0_tl
          index: -1
        }
      ]
      base_addrs:
      {
        null:
        {
          hart: 0x40000000
        }
      }
      generate_dif: true
    }
    {
      name: uart1
      type: uart
      clock_srcs:
      {
        clk_i: io_div4
      }
      clock_group: peri
      reset_connections:
      {
        rst_ni:
        {
          name: lc_io_div4
          domain: Main
        }
      }
      domain: Main
      clock_connections:
      {
        clk_i: clkmgr_clocks_i.clk_io_div4_peri
      }
      param_decl: {}
      memory: {}
      param_list: []
      inter_signal_list:
      [
        {
          name: lsio_trigger
          desc:
            '''
            Self-clearing status trigger for the DMA.
            Set when RX or TX FIFOs are past their configured watermarks matching watermark interrupt behaviour.
            '''
          struct: logic
          type: uni
          act: req
          width: 1
          inst_name: uart1
          index: -1
        }
        {
          name: racl_policies
          desc:
            '''
            Incoming RACL policy vector from a racl_ctrl instance.
            The policy selection vector (parameter) selects the policy for each register.
            '''
          struct: racl_policy_vec
          package: top_racl_pkg
          type: uni
          act: rcv
          width: 1
          inst_name: uart1
          index: -1
        }
        {
          name: racl_error
          desc: RACL error log information of this module.
          struct: racl_error_log
          package: top_racl_pkg
          type: uni
          act: req
          width: 1
          inst_name: uart1
          index: -1
        }
        {
          name: tl
          struct: tl
          package: tlul_pkg
          type: req_rsp
          act: rsp
          width: 1
          inst_name: uart1
          default: ""
          end_idx: -1
          top_type: one-to-one
          top_signame: uart1_tl
          index: -1
        }
      ]
      base_addrs:
      {
        null:
        {
          hart: 0x40010000
        }
      }
      generate_dif: true
    }
    {
      name: uart2
      type: uart
      clock_srcs:
      {
        clk_i: io_div4
      }
      clock_group: peri
      reset_connections:
      {
        rst_ni:
        {
          name: lc_io_div4
          domain: Main
        }
      }
      domain: Main
      clock_connections:
      {
        clk_i: clkmgr_clocks_i.clk_io_div4_peri
      }
      param_decl: {}
      memory: {}
      param_list: []
      inter_signal_list:
      [
        {
          name: lsio_trigger
          desc:
            '''
            Self-clearing status trigger for the DMA.
            Set when RX or TX FIFOs are past their configured watermarks matching watermark interrupt behaviour.
            '''
          struct: logic
          type: uni
          act: req
          width: 1
          inst_name: uart2
          index: -1
        }
        {
          name: racl_policies
          desc:
            '''
            Incoming RACL policy vector from a racl_ctrl instance.
            The policy selection vector (parameter) selects the policy for each register.
            '''
          struct: racl_policy_vec
          package: top_racl_pkg
          type: uni
          act: rcv
          width: 1
          inst_name: uart2
          index: -1
        }
        {
          name: racl_error
          desc: RACL error log information of this module.
          struct: racl_error_log
          package: top_racl_pkg
          type: uni
          act: req
          width: 1
          inst_name: uart2
          index: -1
        }
        {
          name: tl
          struct: tl
          package: tlul_pkg
          type: req_rsp
          act: rsp
          width: 1
          inst_name: uart2
          default: ""
          end_idx: -1
          top_type: one-to-one
          top_signame: uart2_tl
          index: -1
        }
      ]
      base_addrs:
      {
        null:
        {
          hart: 0x40020000
        }
      }
      generate_dif: true
    }
    {
      name: uart3
      type: uart
      clock_srcs:
      {
        clk_i: io_div4
      }
      clock_group: peri
      reset_connections:
      {
        rst_ni:
        {
          name: lc_io_div4
          domain: Main
        }
      }
      domain: Main
      clock_connections:
      {
        clk_i: clkmgr_clocks_i.clk_io_div4_peri
      }
      param_decl: {}
      memory: {}
      param_list: []
      inter_signal_list:
      [
        {
          name: lsio_trigger
          desc:
            '''
            Self-clearing status trigger for the DMA.
            Set when RX or TX FIFOs are past their configured watermarks matching watermark interrupt behaviour.
            '''
          struct: logic
          type: uni
          act: req
          width: 1
          inst_name: uart3
          index: -1
        }
        {
          name: racl_policies
          desc:
            '''
            Incoming RACL policy vector from a racl_ctrl instance.
            The policy selection vector (parameter) selects the policy for each register.
            '''
          struct: racl_policy_vec
          package: top_racl_pkg
          type: uni
          act: rcv
          width: 1
          inst_name: uart3
          index: -1
        }
        {
          name: racl_error
          desc: RACL error log information of this module.
          struct: racl_error_log
          package: top_racl_pkg
          type: uni
          act: req
          width: 1
          inst_name: uart3
          index: -1
        }
        {
          name: tl
          struct: tl
          package: tlul_pkg
          type: req_rsp
          act: rsp
          width: 1
          inst_name: uart3
          default: ""
          end_idx: -1
          top_type: one-to-one
          top_signame: uart3_tl
          index: -1
        }
      ]
      base_addrs:
      {
        null:
        {
          hart: 0x40030000
        }
      }
      generate_dif: true
    }
    {
      name: gpio0
      type: gpio
      template_type: gpio
      clock_srcs:
      {
        clk_i: io_div4
      }
      clock_group: peri
      reset_connections:
      {
        rst_ni:
        {
          name: lc_io_div4
          domain: Main
        }
      }
      param_decl:
      {
        GpioAsHwStrapsEn: "0"
        GpioAsyncOn: "1"
      }
      ipgen_params:
      {
        per_pin_view: true
      }
      attr: ipgen
      domain: Main
      clock_connections:
      {
        clk_i: clkmgr_clocks_i.clk_io_div4_peri
      }
      memory: {}
      param_list:
      [
        {
          name: GpioAsyncOn
          desc: Instantiates 2-flop synchronizers on all GPIO inputs if set to 1.
          type: bit
          default: "1"
          local: "false"
          expose: "true"
          name_top: Gpio0GpioAsyncOn
        }
        {
          name: GpioAsHwStrapsEn
          desc: Enable HW straps sampling logic for GPIO inputs at initial cold boot
          type: bit
          default: "0"
          local: "false"
          expose: "true"
          name_top: Gpio0GpioAsHwStrapsEn
        }
      ]
      inter_signal_list:
      [
        {
          name: strap_en
          desc:
            '''
            The strap enable signal tells gpio to take a snapshot of the input pins.
            The behaviour of this signal after that event will have no effect.
            '''
          struct: logic
          type: uni
          act: rcv
          width: 1
          default: 1'b0
          inst_name: gpio0
          index: -1
        }
        {
          name: sampled_straps
          desc: This vector contains the sampled strap values.
          struct: gpio_straps
          package: gpio_pkg
          type: uni
          act: req
          width: 1
          default: "'0"
          inst_name: gpio0
          index: -1
        }
        {
          name: racl_policies
          desc:
            '''
            Incoming RACL policy vector from a racl_ctrl instance.
            The policy selection vector (parameter) selects the policy for each register.
            '''
          struct: racl_policy_vec
          package: top_racl_pkg
          type: uni
          act: rcv
          width: 1
          inst_name: gpio0
          index: -1
        }
        {
          name: racl_error
          desc: RACL error log information of this module.
          struct: racl_error_log
          package: top_racl_pkg
          type: uni
          act: req
          width: 1
          inst_name: gpio0
          index: -1
        }
        {
          name: tl
          struct: tl
          package: tlul_pkg
          type: req_rsp
          act: rsp
          width: 1
          inst_name: gpio0
          default: ""
          end_idx: -1
          top_type: one-to-one
          top_signame: gpio0_tl
          index: -1
        }
      ]
      base_addrs:
      {
        null:
        {
          hart: 0x40040000
        }
      }
      generate_dif: true
    }
    {
      name: gpio1
      type: gpio
      template_type: gpio
      clock_srcs:
      {
        clk_i: io_div4
      }
      clock_group: peri
      reset_connections:
      {
        rst_ni:
        {
          name: lc_io_div4
          domain: Main
        }
      }
      param_decl:
      {
        GpioAsHwStrapsEn: "0"
        GpioAsyncOn: "1"
      }
      ipgen_params:
      {
        per_pin_view: true
      }
      attr: ipgen
      domain: Main
      clock_connections:
      {
        clk_i: clkmgr_clocks_i.clk_io_div4_peri
      }
      memory: {}
      param_list:
      [
        {
          name: GpioAsyncOn
          desc: Instantiates 2-flop synchronizers on all GPIO inputs if set to 1.
          type: bit
          default: "1"
          local: "false"
          expose: "true"
          name_top: Gpio1GpioAsyncOn
        }
        {
          name: GpioAsHwStrapsEn
          desc: Enable HW straps sampling logic for GPIO inputs at initial cold boot
          type: bit
          default: "0"
          local: "false"
          expose: "true"
          name_top: Gpio1GpioAsHwStrapsEn
        }
      ]
      inter_signal_list:
      [
        {
          name: strap_en
          desc:
            '''
            The strap enable signal tells gpio to take a snapshot of the input pins.
            The behaviour of this signal after that event will have no effect.
            '''
          struct: logic
          type: uni
          act: rcv
          width: 1
          default: 1'b0
          inst_name: gpio1
          index: -1
        }
        {
          name: sampled_straps
          desc: This vector contains the sampled strap values.
          struct: gpio_straps
          package: gpio_pkg
          type: uni
          act: req
          width: 1
          default: "'0"
          inst_name: gpio1
          index: -1
        }
        {
          name: racl_policies
          desc:
            '''
            Incoming RACL policy vector from a racl_ctrl instance.
            The policy selection vector (parameter) selects the policy for each register.
            '''
          struct: racl_policy_vec
          package: top_racl_pkg
          type: uni
          act: rcv
          width: 1
          inst_name: gpio1
          index: -1
        }
        {
          name: racl_error
          desc: RACL error log information of this module.
          struct: racl_error_log
          package: top_racl_pkg
          type: uni
          act: req
          width: 1
          inst_name: gpio1
          index: -1
        }
        {
          name: tl
          struct: tl
          package: tlul_pkg
          type: req_rsp
          act: rsp
          width: 1
          inst_name: gpio1
          default: ""
          end_idx: -1
          top_type: one-to-one
          top_signame: gpio1_tl
          index: -1
        }
      ]
      base_addrs:
      {
        null:
        {
          hart: 0x40050000
        }
      }
      generate_dif: true
    }
    {
      name: spi_device
      type: spi_device
      clock_srcs:
      {
        clk_i: io_div4
        scan_clk_i: io_div4
      }
      clock_group: peri
      reset_connections:
      {
        rst_ni:
        {
          name: spi_device
          domain: Main
        }
      }
      param_decl:
      {
        SramType: spi_device_pkg::SramType1r1w
      }
      domain: Main
      clock_connections:
      {
        clk_i: clkmgr_clocks_i.clk_io_div4_peri
        scan_clk_i: clkmgr_clocks_i.clk_io_div4_peri
      }
      memory: {}
      param_list:
      [
        {
          name: SramType
          desc: Sram Entries. Word size is 32bit width.
          type: spi_device_pkg::sram_type_e
          default: spi_device_pkg::SramType1r1w
          local: "false"
          expose: "true"
          name_top: SpiDeviceSramType
        }
      ]
      inter_signal_list:
      [
        {
          name: ram_cfg_sys2spi
          struct: ram_1r1w_cfg
          package: prim_ram_1r1w_pkg
          type: req_rsp
          act: rsp
          width: 1
          inst_name: spi_device
          default: ""
          top_signame: spi_device_ram_cfg_sys2spi
          index: -1
        }
        {
          name: ram_cfg_spi2sys
          struct: ram_1r1w_cfg
          package: prim_ram_1r1w_pkg
          type: req_rsp
          act: rsp
          width: 1
          inst_name: spi_device
          default: ""
          top_signame: spi_device_ram_cfg_spi2sys
          index: -1
        }
        {
          name: passthrough
          struct: passthrough
          package: spi_device_pkg
          type: req_rsp
          act: req
          width: 1
          inst_name: spi_device
          default: ""
          end_idx: -1
          top_type: one-to-one
          top_signame: spi_device_passthrough
          index: -1
        }
        {
          name: mbist_en
          struct: logic
          type: uni
          act: rcv
          width: 1
          inst_name: spi_device
          index: -1
        }
        {
          name: sck_monitor
          struct: logic
          type: uni
          act: req
          width: 1
          inst_name: spi_device
          index: -1
        }
        {
          name: racl_policies
          desc:
            '''
            Incoming RACL policy vector from a racl_ctrl instance.
            The policy selection vector (parameter) selects the policy for each register.
            '''
          struct: racl_policy_vec
          package: top_racl_pkg
          type: uni
          act: rcv
          width: 1
          inst_name: spi_device
          index: -1
        }
        {
          name: racl_error
          desc: RACL error log information of this module.
          struct: racl_error_log
          package: top_racl_pkg
          type: uni
          act: req
          width: 1
          inst_name: spi_device
          index: -1
        }
        {
          name: tl
          struct: tl
          package: tlul_pkg
          type: req_rsp
          act: rsp
          width: 1
          inst_name: spi_device
          default: ""
          end_idx: -1
          top_type: one-to-one
          top_signame: spi_device_tl
          index: -1
        }
      ]
      base_addrs:
      {
        null:
        {
          hart: 0x40060000
        }
      }
      generate_dif: true
    }
    {
      name: i2c0
      type: i2c
      clock_srcs:
      {
        clk_i: io_div4
      }
      clock_group: peri
      reset_connections:
      {
        rst_ni:
        {
          name: i2c0
          domain: Main
        }
      }
      domain: Main
      clock_connections:
      {
        clk_i: clkmgr_clocks_i.clk_io_div4_peri
      }
      param_decl: {}
      memory: {}
      param_list:
      [
        {
          name: InputDelayCycles
          desc:
            '''
            Maximum number of cycles of propagation delay between a change on the cio_scl_en_o or cio_sda_en_o pins and sensing the new values on the corresponding input pins, not including the rise/fall times.
            For the purposes of this calculation, an input delay of 0 cycles means an output pin changing at the beginning of clock edge N will be sampled and observed on the input pins at clock edge N+1.
            '''
          type: int
          default: "0"
          local: "false"
          expose: "true"
          name_top: I2c0InputDelayCycles
        }
      ]
      inter_signal_list:
      [
        {
          name: ram_cfg
          struct: ram_1p_cfg
          package: prim_ram_1p_pkg
          type: req_rsp
          act: rsp
          width: 1
          inst_name: i2c0
          default: ""
          top_signame: i2c0_ram_cfg
          index: -1
        }
        {
          name: lsio_trigger
          desc:
            '''
            Self-clearing status trigger for the DMA.
            Set when RX TX FIFO is past their configured watermark matching watermark interrupt behaviour.
            '''
          struct: logic
          type: uni
          act: req
          width: 1
          inst_name: i2c0
          index: -1
        }
        {
          name: racl_policies
          desc:
            '''
            Incoming RACL policy vector from a racl_ctrl instance.
            The policy selection vector (parameter) selects the policy for each register.
            '''
          struct: racl_policy_vec
          package: top_racl_pkg
          type: uni
          act: rcv
          width: 1
          inst_name: i2c0
          index: -1
        }
        {
          name: racl_error
          desc: RACL error log information of this module.
          struct: racl_error_log
          package: top_racl_pkg
          type: uni
          act: req
          width: 1
          inst_name: i2c0
          index: -1
        }
        {
          name: tl
          struct: tl
          package: tlul_pkg
          type: req_rsp
          act: rsp
          width: 1
          inst_name: i2c0
          default: ""
          end_idx: -1
          top_type: one-to-one
          top_signame: i2c0_tl
          index: -1
        }
      ]
      base_addrs:
      {
        null:
        {
          hart: 0x40080000
        }
      }
      generate_dif: true
    }
    {
      name: i2c1
      type: i2c
      clock_srcs:
      {
        clk_i: io_div4
      }
      clock_group: peri
      reset_connections:
      {
        rst_ni:
        {
          name: i2c1
          domain: Main
        }
      }
      domain: Main
      clock_connections:
      {
        clk_i: clkmgr_clocks_i.clk_io_div4_peri
      }
      param_decl: {}
      memory: {}
      param_list:
      [
        {
          name: InputDelayCycles
          desc:
            '''
            Maximum number of cycles of propagation delay between a change on the cio_scl_en_o or cio_sda_en_o pins and sensing the new values on the corresponding input pins, not including the rise/fall times.
            For the purposes of this calculation, an input delay of 0 cycles means an output pin changing at the beginning of clock edge N will be sampled and observed on the input pins at clock edge N+1.
            '''
          type: int
          default: "0"
          local: "false"
          expose: "true"
          name_top: I2c1InputDelayCycles
        }
      ]
      inter_signal_list:
      [
        {
          name: ram_cfg
          struct: ram_1p_cfg
          package: prim_ram_1p_pkg
          type: req_rsp
          act: rsp
          width: 1
          inst_name: i2c1
          default: ""
          top_signame: i2c1_ram_cfg
          index: -1
        }
        {
          name: lsio_trigger
          desc:
            '''
            Self-clearing status trigger for the DMA.
            Set when RX TX FIFO is past their configured watermark matching watermark interrupt behaviour.
            '''
          struct: logic
          type: uni
          act: req
          width: 1
          inst_name: i2c1
          index: -1
        }
        {
          name: racl_policies
          desc:
            '''
            Incoming RACL policy vector from a racl_ctrl instance.
            The policy selection vector (parameter) selects the policy for each register.
            '''
          struct: racl_policy_vec
          package: top_racl_pkg
          type: uni
          act: rcv
          width: 1
          inst_name: i2c1
          index: -1
        }
        {
          name: racl_error
          desc: RACL error log information of this module.
          struct: racl_error_log
          package: top_racl_pkg
          type: uni
          act: req
          width: 1
          inst_name: i2c1
          index: -1
        }
        {
          name: tl
          struct: tl
          package: tlul_pkg
          type: req_rsp
          act: rsp
          width: 1
          inst_name: i2c1
          default: ""
          end_idx: -1
          top_type: one-to-one
          top_signame: i2c1_tl
          index: -1
        }
      ]
      base_addrs:
      {
        null:
        {
          hart: 0x40090000
        }
      }
      generate_dif: true
    }
    {
      name: i2c2
      type: i2c
      clock_srcs:
      {
        clk_i: io_div4
      }
      clock_group: peri
      reset_connections:
      {
        rst_ni:
        {
          name: i2c2
          domain: Main
        }
      }
      domain: Main
      clock_connections:
      {
        clk_i: clkmgr_clocks_i.clk_io_div4_peri
      }
      param_decl: {}
      memory: {}
      param_list:
      [
        {
          name: InputDelayCycles
          desc:
            '''
            Maximum number of cycles of propagation delay between a change on the cio_scl_en_o or cio_sda_en_o pins and sensing the new values on the corresponding input pins, not including the rise/fall times.
            For the purposes of this calculation, an input delay of 0 cycles means an output pin changing at the beginning of clock edge N will be sampled and observed on the input pins at clock edge N+1.
            '''
          type: int
          default: "0"
          local: "false"
          expose: "true"
          name_top: I2c2InputDelayCycles
        }
      ]
      inter_signal_list:
      [
        {
          name: ram_cfg
          struct: ram_1p_cfg
          package: prim_ram_1p_pkg
          type: req_rsp
          act: rsp
          width: 1
          inst_name: i2c2
          default: ""
          top_signame: i2c2_ram_cfg
          index: -1
        }
        {
          name: lsio_trigger
          desc:
            '''
            Self-clearing status trigger for the DMA.
            Set when RX TX FIFO is past their configured watermark matching watermark interrupt behaviour.
            '''
          struct: logic
          type: uni
          act: req
          width: 1
          inst_name: i2c2
          index: -1
        }
        {
          name: racl_policies
          desc:
            '''
            Incoming RACL policy vector from a racl_ctrl instance.
            The policy selection vector (parameter) selects the policy for each register.
            '''
          struct: racl_policy_vec
          package: top_racl_pkg
          type: uni
          act: rcv
          width: 1
          inst_name: i2c2
          index: -1
        }
        {
          name: racl_error
          desc: RACL error log information of this module.
          struct: racl_error_log
          package: top_racl_pkg
          type: uni
          act: req
          width: 1
          inst_name: i2c2
          index: -1
        }
        {
          name: tl
          struct: tl
          package: tlul_pkg
          type: req_rsp
          act: rsp
          width: 1
          inst_name: i2c2
          default: ""
          end_idx: -1
          top_type: one-to-one
          top_signame: i2c2_tl
          index: -1
        }
      ]
      base_addrs:
      {
        null:
        {
          hart: 0x400A0000
        }
      }
      generate_dif: true
    }
    {
      name: i3c0
      type: i3c
      clock_srcs:
      {
        clk_i: io
        clk_aon_i: aon
        scan_clk_i: io_div4
      }
      clock_group: peri
      reset_connections:
      {
        rst_ni:
        {
          name: i3c0
          domain: Main
        }
        rst_aon_ni:
        {
          name: lc_aon
          domain: Main
        }
      }
      domain: Main
      domain_secondary: Aon
      param_decl:
      {
        ClkFreq: "96000000"
        HalfCycleScl: "1"
        NumTargets: "2"
      }
      clock_srcs_secondary:
      {
        clk_aon_i: aon
      }
      clock_group_secondary: peri
      reset_connections_secondary:
      {
        rst_aon_ni:
        {
          name: lc_aon
          domain: Aon
        }
      }
      clock_connections:
      {
        clk_i: clkmgr_clocks_i.clk_io_peri
        clk_aon_i: clkmgr_clocks_i.clk_aon_peri
        scan_clk_i: clkmgr_clocks_i.clk_io_div4_peri
      }
      clock_connections_secondary:
      {
        clk_aon_i: clkmgr_clocks.clk_aon_peri
      }
      is_split_ip: true
      memory: {}
      param_list:
      [
        {
          name: ClkFreq
          desc: The frequency of the main clock, in Hz.
          type: int unsigned
          default: "96000000"
          local: "false"
          expose: "true"
          name_top: I3c0ClkFreq
        }
        {
          name: PrimaryCtrl
          desc: Disable(0) or enable(1) Primary Controller role.
          type: bit
          default: 1'b1
          local: "false"
          expose: "true"
          name_top: I3c0PrimaryCtrl
        }
        {
          name: SecondaryCtrl
          desc: Disable(0) or enable(1) Secondary Controller role.
          type: bit
          default: 1'b0
          local: "false"
          expose: "true"
          name_top: I3c0SecondaryCtrl
        }
        {
          name: Target
          desc:
            '''
            Disable(0) or enable(1) Target functionality even in the absence of a role as
            Secondary Controller.
            '''
          type: bit
          default: 1'b1
          local: "false"
          expose: "true"
          name_top: I3c0Target
        }
        {
          name: NumTargets
          desc:
            '''
            Number of target(s) or target group(s) presented simultaneously on the I3C bus,
            including the Secondary Controller Role on (Virtual) Target 0. This must not exceed
            `MaxTargets`, for which all Target-indexed data types are sized; the surplus slices
            of an instance with fewer Targets are tied off.
            '''
          type: int unsigned
          default: "2"
          local: "false"
          expose: "true"
          name_top: I3c0NumTargets
        }
        {
          name: SWDirectMsgBuf
          desc: Disable(0) or enable(1) direct software access to the message buffer.
          type: bit
          default: 1'b1
          local: "false"
          expose: "true"
          name_top: I3c0SWDirectMsgBuf
        }
        {
          name: SWDirEnIFetch
          desc: Disable(0) or enable(1) software execution through direct message buffer access.
          type: bit
          default: 1'b0
          local: "false"
          expose: "true"
          name_top: I3c0SWDirEnIFetch
        }
        {
          name: CompManufacturer
          desc: Hardware Identification Extended Capability: Component manufacturer.
          type: logic [31:0]
          default: i3c_pkg::CompManufacturer
          local: "false"
          expose: "true"
          name_top: I3c0CompManufacturer
        }
        {
          name: CompVersion
          desc: Hardware Identification Extended Capability: Component version.
          type: logic [31:0]
          default: i3c_pkg::CompVersion
          local: "false"
          expose: "true"
          name_top: I3c0CompVersion
        }
        {
          name: CompType
          desc: Hardware Identification Extended Capability: Component type.
          type: logic [31:0]
          default: i3c_pkg::CompType
          local: "false"
          expose: "true"
          name_top: I3c0CompType
        }
        {
          name: HalfCycleScl
          desc: Disable(0) or enable(1) half-cycle SCL extension for additional IP clock frequency support.
          type: bit
          default: "1"
          local: "false"
          expose: "true"
          name_top: I3c0HalfCycleScl
        }
        {
          name: TargetExt
          desc: Disable(0) or enable(1) Target-side Extension hardware.
          type: bit
          default: 1'b0
          local: "false"
          expose: "true"
          name_top: I3c0TargetExt
        }
      ]
      inter_signal_list:
      [
        {
          name: rstdet_enable
          desc: Enables the SCL/SDA inputs of the Target Reset Detector in the secondary partition; deasserted while the Target is disconnected from the bus.
          struct: logic
          type: uni
          act: req
          width: 1
          inst_name: i3c0
          default: ""
          package: ""
          end_idx: -1
          top_type: broadcast
          top_signame: i3c0_rstdet_enable
          index: -1
          external: true
          conn_type: false
        }
        {
          name: rstdet_enable
          desc: Enables the SCL/SDA inputs of the Target Reset Detector; deasserted while the Target is disconnected from the bus.
          struct: logic
          type: uni
          act: rcv
          width: 1
          partition: secondary
          inst_name: i3c0
          default: ""
          package: ""
          domain: Aon
          top_signame: i3c0_rstdet_enable
          index: -1
          external: true
          conn_type: false
        }
        {
          name: rstdet
          desc: Control and status interface to the Target Reset Detector in the secondary partition.
          struct: i3c_rstdet
          package: i3c_pkg
          type: req_rsp
          act: req
          width: 1
          inst_name: i3c0
          default: ""
          end_idx: -1
          top_type: one-to-one
          top_signame: i3c0_rstdet
          index: -1
          external: true
          conn_type: false
        }
        {
          name: rstdet
          desc: Control and status interface of the Target Reset Detector to the primary partition.
          struct: i3c_rstdet
          package: i3c_pkg
          type: req_rsp
          act: rsp
          width: 1
          partition: secondary
          inst_name: i3c0
          default: ""
          domain: Aon
          top_signame: i3c0_rstdet
          index: -1
          external: true
          conn_type: false
        }
        {
          name: rstdet_wkup_req
          desc: Wake-up request on detection of the Target Reset Pattern.
          struct: logic
          type: uni
          act: req
          width: 1
          partition: secondary
          inst_name: i3c0
          default: ""
          package: ""
          domain: Aon
          top_signame: pwrmgr_wakeups
          index: 0
        }
        {
          name: rstdet_target_rst
          desc: Reset request for the I3C peripheral on detection of the Target Reset Pattern.
          struct: logic
          type: uni
          act: req
          width: 1
          partition: secondary
          inst_name: i3c0
          index: -1
        }
        {
          name: mbist_en
          desc: Memory built-in self-test enable (unused).
          struct: logic
          type: uni
          act: rcv
          width: 1
          inst_name: i3c0
          index: -1
        }
        {
          name: scl_hk_en
          desc: I3C Controller clock High-keeper enable output
          struct: logic
          type: uni
          act: req
          width: 1
          inst_name: i3c0
          index: -1
        }
        {
          name: sda_hk_en
          desc: I3C Controller data High-keeper enable output
          struct: logic
          type: uni
          act: req
          width: 1
          inst_name: i3c0
          index: -1
        }
        {
          name: ctrl_scl_pu_en
          desc: I3C Controller clock Pullup enable output
          struct: logic
          type: uni
          act: req
          width: 1
          inst_name: i3c0
          index: -1
        }
        {
          name: ram_cfg
          desc: RAM configuration of the message buffer memory.
          struct: ram_1p_cfg
          package: prim_ram_1p_pkg
          type: req_rsp
          act: rsp
          width: 1
          inst_name: i3c0
          default: ""
          top_signame: i3c0_ram_cfg
          index: -1
        }
        {
          name: dat_cfg
          desc: RAM configuration of the Device Address Table (DAT) memory.
          struct: ram_1p_cfg
          package: prim_ram_1p_pkg
          type: req_rsp
          act: rsp
          width: 1
          inst_name: i3c0
          default: ""
          top_signame: i3c0_dat_cfg
          index: -1
        }
        {
          name: dct_cfg
          desc: RAM configuration of the Device Characteristics Table (DCT) memory.
          struct: ram_1p_cfg
          package: prim_ram_1p_pkg
          type: req_rsp
          act: rsp
          width: 1
          inst_name: i3c0
          default: ""
          top_signame: i3c0_dct_cfg
          index: -1
        }
        {
          name: racl_policies
          desc:
            '''
            Incoming RACL policy vector from a racl_ctrl instance.
            The policy selection vector (parameter) selects the policy for each register.
            '''
          struct: racl_policy_vec
          package: top_racl_pkg
          type: uni
          act: rcv
          width: 1
          inst_name: i3c0
          index: -1
        }
        {
          name: racl_error
          desc: RACL error log information of this module.
          struct: racl_error_log
          package: top_racl_pkg
          type: uni
          act: req
          width: 1
          inst_name: i3c0
          index: -1
        }
        {
          name: tl
          struct: tl
          package: tlul_pkg
          type: req_rsp
          act: rsp
          width: 1
          inst_name: i3c0
          default: ""
          end_idx: -1
          top_type: one-to-one
          top_signame: i3c0_tl
          index: -1
        }
      ]
      base_addrs:
      {
        null:
        {
          hart: 0x40330000
        }
      }
      generate_dif: true
    }
    {
      name: i3c1
      type: i3c
      clock_srcs:
      {
        clk_i: io
        clk_aon_i: aon
        scan_clk_i: io_div4
      }
      clock_group: peri
      reset_connections:
      {
        rst_ni:
        {
          name: i3c1
          domain: Main
        }
        rst_aon_ni:
        {
          name: lc_aon
          domain: Main
        }
      }
      domain: Main
      domain_secondary: Main
      param_decl:
      {
        ClkFreq: "96000000"
        HalfCycleScl: "1"
        NumTargets: "2"
      }
      clock_srcs_secondary:
      {
        clk_aon_i: aon
      }
      clock_group_secondary: peri
      reset_connections_secondary:
      {
        rst_aon_ni:
        {
          name: lc_aon
          domain: Main
        }
      }
      clock_connections:
      {
        clk_i: clkmgr_clocks_i.clk_io_peri
        clk_aon_i: clkmgr_clocks_i.clk_aon_peri
        scan_clk_i: clkmgr_clocks_i.clk_io_div4_peri
      }
      clock_connections_secondary:
      {
        clk_aon_i: clkmgr_clocks_i.clk_aon_peri
      }
      is_split_ip: true
      memory: {}
      param_list:
      [
        {
          name: ClkFreq
          desc: The frequency of the main clock, in Hz.
          type: int unsigned
          default: "96000000"
          local: "false"
          expose: "true"
          name_top: I3c1ClkFreq
        }
        {
          name: PrimaryCtrl
          desc: Disable(0) or enable(1) Primary Controller role.
          type: bit
          default: 1'b1
          local: "false"
          expose: "true"
          name_top: I3c1PrimaryCtrl
        }
        {
          name: SecondaryCtrl
          desc: Disable(0) or enable(1) Secondary Controller role.
          type: bit
          default: 1'b0
          local: "false"
          expose: "true"
          name_top: I3c1SecondaryCtrl
        }
        {
          name: Target
          desc:
            '''
            Disable(0) or enable(1) Target functionality even in the absence of a role as
            Secondary Controller.
            '''
          type: bit
          default: 1'b1
          local: "false"
          expose: "true"
          name_top: I3c1Target
        }
        {
          name: NumTargets
          desc:
            '''
            Number of target(s) or target group(s) presented simultaneously on the I3C bus,
            including the Secondary Controller Role on (Virtual) Target 0. This must not exceed
            `MaxTargets`, for which all Target-indexed data types are sized; the surplus slices
            of an instance with fewer Targets are tied off.
            '''
          type: int unsigned
          default: "2"
          local: "false"
          expose: "true"
          name_top: I3c1NumTargets
        }
        {
          name: SWDirectMsgBuf
          desc: Disable(0) or enable(1) direct software access to the message buffer.
          type: bit
          default: 1'b1
          local: "false"
          expose: "true"
          name_top: I3c1SWDirectMsgBuf
        }
        {
          name: SWDirEnIFetch
          desc: Disable(0) or enable(1) software execution through direct message buffer access.
          type: bit
          default: 1'b0
          local: "false"
          expose: "true"
          name_top: I3c1SWDirEnIFetch
        }
        {
          name: CompManufacturer
          desc: Hardware Identification Extended Capability: Component manufacturer.
          type: logic [31:0]
          default: i3c_pkg::CompManufacturer
          local: "false"
          expose: "true"
          name_top: I3c1CompManufacturer
        }
        {
          name: CompVersion
          desc: Hardware Identification Extended Capability: Component version.
          type: logic [31:0]
          default: i3c_pkg::CompVersion
          local: "false"
          expose: "true"
          name_top: I3c1CompVersion
        }
        {
          name: CompType
          desc: Hardware Identification Extended Capability: Component type.
          type: logic [31:0]
          default: i3c_pkg::CompType
          local: "false"
          expose: "true"
          name_top: I3c1CompType
        }
        {
          name: HalfCycleScl
          desc: Disable(0) or enable(1) half-cycle SCL extension for additional IP clock frequency support.
          type: bit
          default: "1"
          local: "false"
          expose: "true"
          name_top: I3c1HalfCycleScl
        }
        {
          name: TargetExt
          desc: Disable(0) or enable(1) Target-side Extension hardware.
          type: bit
          default: 1'b0
          local: "false"
          expose: "true"
          name_top: I3c1TargetExt
        }
      ]
      inter_signal_list:
      [
        {
          name: rstdet_enable
          desc: Enables the SCL/SDA inputs of the Target Reset Detector in the secondary partition; deasserted while the Target is disconnected from the bus.
          struct: logic
          type: uni
          act: req
          width: 1
          inst_name: i3c1
          default: ""
          package: ""
          end_idx: -1
          top_type: broadcast
          top_signame: i3c1_rstdet_enable
          index: -1
        }
        {
          name: rstdet_enable
          desc: Enables the SCL/SDA inputs of the Target Reset Detector; deasserted while the Target is disconnected from the bus.
          struct: logic
          type: uni
          act: rcv
          width: 1
          partition: secondary
          inst_name: i3c1
          default: ""
          package: ""
          domain: Main
          top_signame: i3c1_rstdet_enable
          index: -1
        }
        {
          name: rstdet
          desc: Control and status interface to the Target Reset Detector in the secondary partition.
          struct: i3c_rstdet
          package: i3c_pkg
          type: req_rsp
          act: req
          width: 1
          inst_name: i3c1
          default: ""
          end_idx: -1
          top_type: one-to-one
          top_signame: i3c1_rstdet
          index: -1
        }
        {
          name: rstdet
          desc: Control and status interface of the Target Reset Detector to the primary partition.
          struct: i3c_rstdet
          package: i3c_pkg
          type: req_rsp
          act: rsp
          width: 1
          partition: secondary
          inst_name: i3c1
          default: ""
          domain: Main
          top_signame: i3c1_rstdet
          index: -1
        }
        {
          name: rstdet_wkup_req
          desc: Wake-up request on detection of the Target Reset Pattern.
          struct: logic
          type: uni
          act: req
          width: 1
          partition: secondary
          inst_name: i3c1
          default: ""
          package: ""
          domain: Main
          top_signame: pwrmgr_wakeups
          index: -1
          external: true
          conn_type: false
        }
        {
          name: rstdet_target_rst
          desc: Reset request for the I3C peripheral on detection of the Target Reset Pattern.
          struct: logic
          type: uni
          act: req
          width: 1
          partition: secondary
          inst_name: i3c1
          index: -1
        }
        {
          name: mbist_en
          desc: Memory built-in self-test enable (unused).
          struct: logic
          type: uni
          act: rcv
          width: 1
          inst_name: i3c1
          index: -1
        }
        {
          name: scl_hk_en
          desc: I3C Controller clock High-keeper enable output
          struct: logic
          type: uni
          act: req
          width: 1
          inst_name: i3c1
          index: -1
        }
        {
          name: sda_hk_en
          desc: I3C Controller data High-keeper enable output
          struct: logic
          type: uni
          act: req
          width: 1
          inst_name: i3c1
          index: -1
        }
        {
          name: ctrl_scl_pu_en
          desc: I3C Controller clock Pullup enable output
          struct: logic
          type: uni
          act: req
          width: 1
          inst_name: i3c1
          index: -1
        }
        {
          name: ram_cfg
          desc: RAM configuration of the message buffer memory.
          struct: ram_1p_cfg
          package: prim_ram_1p_pkg
          type: req_rsp
          act: rsp
          width: 1
          inst_name: i3c1
          default: ""
          top_signame: i3c1_ram_cfg
          index: -1
        }
        {
          name: dat_cfg
          desc: RAM configuration of the Device Address Table (DAT) memory.
          struct: ram_1p_cfg
          package: prim_ram_1p_pkg
          type: req_rsp
          act: rsp
          width: 1
          inst_name: i3c1
          default: ""
          top_signame: i3c1_dat_cfg
          index: -1
        }
        {
          name: dct_cfg
          desc: RAM configuration of the Device Characteristics Table (DCT) memory.
          struct: ram_1p_cfg
          package: prim_ram_1p_pkg
          type: req_rsp
          act: rsp
          width: 1
          inst_name: i3c1
          default: ""
          top_signame: i3c1_dct_cfg
          index: -1
        }
        {
          name: racl_policies
          desc:
            '''
            Incoming RACL policy vector from a racl_ctrl instance.
            The policy selection vector (parameter) selects the policy for each register.
            '''
          struct: racl_policy_vec
          package: top_racl_pkg
          type: uni
          act: rcv
          width: 1
          inst_name: i3c1
          index: -1
        }
        {
          name: racl_error
          desc: RACL error log information of this module.
          struct: racl_error_log
          package: top_racl_pkg
          type: uni
          act: req
          width: 1
          inst_name: i3c1
          index: -1
        }
        {
          name: tl
          struct: tl
          package: tlul_pkg
          type: req_rsp
          act: rsp
          width: 1
          inst_name: i3c1
          default: ""
          end_idx: -1
          top_type: one-to-one
          top_signame: i3c1_tl
          index: -1
        }
      ]
      base_addrs:
      {
        null:
        {
          hart: 0x40340000
        }
      }
      generate_dif: true
    }
    {
      name: rv_timer
      type: rv_timer
      clock_srcs:
      {
        clk_i: io_div4
      }
      clock_group: timers
      reset_connections:
      {
        rst_ni:
        {
          name: lc_io_div4
          domain: Main
        }
      }
      domain: Main
      clock_connections:
      {
        clk_i: clkmgr_clocks_i.clk_io_div4_timers
      }
      param_decl: {}
      memory: {}
      param_list: []
      inter_signal_list:
      [
        {
          name: racl_policies
          desc:
            '''
            Incoming RACL policy vector from a racl_ctrl instance.
            The policy selection vector (parameter) selects the policy for each register.
            '''
          struct: racl_policy_vec
          package: top_racl_pkg
          type: uni
          act: rcv
          width: 1
          inst_name: rv_timer
          index: -1
        }
        {
          name: racl_error
          desc: RACL error log information of this module.
          struct: racl_error_log
          package: top_racl_pkg
          type: uni
          act: req
          width: 1
          inst_name: rv_timer
          index: -1
        }
        {
          name: tl
          struct: tl
          package: tlul_pkg
          type: req_rsp
          act: rsp
          width: 1
          inst_name: rv_timer
          default: ""
          end_idx: -1
          top_type: one-to-one
          top_signame: rv_timer_tl
          index: -1
        }
      ]
      base_addrs:
      {
        null:
        {
          hart: 0x40100000
        }
      }
      generate_dif: true
    }
    {
      name: otp_ctrl
      type: otp_ctrl
      template_type: otp_ctrl
      clock_srcs:
      {
        clk_i: io_div4
        clk_edn_i: main
      }
      clock_group: secure
      reset_connections:
      {
        rst_ni:
        {
          name: lc_io_div4
          domain: Main
        }
        rst_edn_ni:
        {
          name: lc
          domain: Main
        }
      }
      base_addrs:
      {
        core:
        {
          hart: 0x40130000
        }
      }
      attr: ipgen
      ipgen_params:
      {
        num_sram_key_req_slots: 5
      }
      domain: Main
      clock_connections:
      {
        clk_i: clkmgr_clocks_i.clk_io_div4_secure
        clk_edn_i: clkmgr_clocks_i.clk_main_secure
      }
      param_decl: {}
      memory: {}
      param_list: []
      inter_signal_list:
      [
        {
          name: edn
          desc: Entropy request to the entropy distribution network for LFSR reseeding and ephemeral key derivation.
          struct: edn
          package: edn_pkg
          type: req_rsp
          act: req
          width: 1
          inst_name: otp_ctrl
          default: ""
          domain: Main
          top_signame: edn0_edn
          index: 1
        }
        {
          name: pwr_otp
          desc: Initialization request/acknowledge from/to power manager.
          struct: pwr_otp
          package: pwrmgr_pkg
          type: req_rsp
          act: rsp
          width: 1
          default: "'0"
          inst_name: otp_ctrl
          domain: Main
          top_signame: pwrmgr_pwr_otp
          index: -1
          external: true
          conn_type: false
        }
        {
          name: lc_otp_program
          desc: Life cycle state transition interface.
          struct: lc_otp_program
          package: otp_ctrl_pkg
          type: req_rsp
          act: rsp
          width: 1
          default: "'0"
          inst_name: otp_ctrl
          domain: Main
          top_signame: lc_ctrl_lc_otp_program
          index: -1
        }
        {
          name: otp_lc_data
          desc:
            '''
            Life cycle state output holding the current life cycle state,
            the value of the transition counter and the tokens needed for life cycle transitions.
            '''
          struct: otp_lc_data
          package: otp_ctrl_pkg
          type: uni
          act: req
          width: 1
          default: "'0"
          inst_name: otp_ctrl
          end_idx: -1
          top_type: broadcast
          top_signame: otp_ctrl_otp_lc_data
          index: -1
        }
        {
          name: lc_escalate_en
          desc:
            '''
            Life cycle escalation enable coming from life cycle controller.
            This signal moves all FSMs within OTP into the error state.
            '''
          struct: lc_tx
          package: lc_ctrl_pkg
          type: uni
          act: rcv
          width: 1
          default: lc_ctrl_pkg::Off
          inst_name: otp_ctrl
          domain: Main
          top_signame: lc_ctrl_lc_escalate_en
          index: -1
        }
        {
          name: lc_creator_seed_sw_rw_en
          desc:
            '''
            Provision enable qualifier coming from life cycle controller.
            This signal enables SW read / write access to the RMA_TOKEN and CREATOR_ROOT_KEY_SHARE0 and CREATOR_ROOT_KEY_SHARE1.
            '''
          struct: lc_tx
          package: lc_ctrl_pkg
          type: uni
          act: rcv
          width: 1
          default: lc_ctrl_pkg::Off
          inst_name: otp_ctrl
          domain: Main
          top_signame: lc_ctrl_lc_creator_seed_sw_rw_en
          index: -1
        }
        {
          name: lc_owner_seed_sw_rw_en
          desc:
            '''
            Provision enable qualifier coming from life cycle controller.
            This signal enables SW read / write access to the OWNER_SEED.
            '''
          struct: lc_tx
          package: lc_ctrl_pkg
          type: uni
          act: rcv
          width: 1
          default: lc_ctrl_pkg::Off
          inst_name: otp_ctrl
          index: -1
        }
        {
          name: lc_seed_hw_rd_en
          desc:
            '''
            Seed read enable coming from life cycle controller.
            This signal enables HW read access to the CREATOR_ROOT_KEY_SHARE0 and CREATOR_ROOT_KEY_SHARE1.
            '''
          struct: lc_tx
          package: lc_ctrl_pkg
          type: uni
          act: rcv
          width: 1
          default: lc_ctrl_pkg::Off
          inst_name: otp_ctrl
          domain: Main
          top_signame: lc_ctrl_lc_seed_hw_rd_en
          index: -1
        }
        {
          name: lc_rma_state
          desc:
            '''
            This signal states whether the current life cycle is RMA.
            It is used to enable SW read access to (read-locked) partitions in the RMA state.
            '''
          struct: lc_tx
          package: lc_ctrl_pkg
          type: uni
          act: rcv
          width: 1
          default: lc_ctrl_pkg::Off
          inst_name: otp_ctrl
          domain: Main
          top_signame: lc_ctrl_lc_rma_state
          index: -1
        }
        {
          name: lc_check_byp_en
          desc:
            '''
            Life cycle partition check bypass signal.
            This signal causes the life cycle partition to bypass consistency checks during life cycle state transitions in order to prevent spurious consistency check failures.
            '''
          struct: lc_tx
          package: lc_ctrl_pkg
          type: uni
          act: rcv
          width: 1
          default: lc_ctrl_pkg::Off
          inst_name: otp_ctrl
          domain: Main
          top_signame: lc_ctrl_lc_check_byp_en
          index: -1
        }
        {
          name: keymgr_creator_root_key
          desc: Key output to the key manager holding CREATOR_ROOT_KEY_SHARE0 and CREATOR_ROOT_KEY_SHARE1.
          struct: keymgr_dpe_creator_root_key
          package: keymgr_dpe_pkg
          type: uni
          act: req
          width: 1
          default: "'0"
          inst_name: otp_ctrl
          end_idx: -1
          top_type: broadcast
          top_signame: otp_ctrl_keymgr_creator_root_key
          index: -1
        }
        {
          name: keymgr_creator_seed
          desc: Creator seed output to the key manager
          struct: keymgr_dpe_creator_seed
          package: keymgr_dpe_pkg
          type: uni
          act: req
          width: 1
          default: "'0"
          inst_name: otp_ctrl
          index: -1
        }
        {
          name: keymgr_owner_seed
          desc: Owner seed output to the key manager
          struct: keymgr_dpe_owner_seed
          package: keymgr_dpe_pkg
          type: uni
          act: req
          width: 1
          default: "'0"
          inst_name: otp_ctrl
          index: -1
        }
        {
          name: nvm_otp_key
          desc: Key derivation interface for NVM scrambling.
          struct: nvm_otp_key
          package: otp_ctrl_pkg
          type: req_rsp
          act: rsp
          width: 1
          default: "'0"
          inst_name: otp_ctrl
          domain: Main
          top_signame: rram_ctrl_otp_key
          index: -1
        }
        {
          name: sram_otp_key
          desc: Array with key derivation interfaces for SRAM scrambling devices.
          struct: sram_otp_key
          package: otp_ctrl_pkg
          type: req_rsp
          act: rsp
          width: 5
          default: "'0"
          inst_name: otp_ctrl
          end_idx: -1
          top_type: one-to-N
          top_signame: otp_ctrl_sram_otp_key
          index: 2
          external: true
          conn_type: true
        }
        {
          name: otbn_otp_key
          desc: Key derivation interface for OTBN scrambling devices.
          struct: otbn_otp_key
          package: otp_ctrl_pkg
          type: req_rsp
          act: rsp
          width: 1
          default: "'0"
          inst_name: otp_ctrl
          end_idx: -1
          top_type: one-to-one
          top_signame: otp_ctrl_otbn_otp_key
          index: -1
        }
        {
          name: otp_broadcast
          desc: Output of the HW partitions with breakout data types.
          struct: otp_broadcast
          package: otp_ctrl_part_pkg
          type: uni
          act: req
          width: 1
          default: "'0"
          inst_name: otp_ctrl
          top_signame: otp_ctrl_otp_broadcast
          index: -1
        }
        {
          name: otp_macro
          desc: Data interface for the OTP macro.
          struct: otp_ctrl_macro
          package: otp_ctrl_macro_pkg
          type: req_rsp
          act: req
          width: 1
          default: "'0"
          inst_name: otp_ctrl
          end_idx: -1
          top_type: one-to-one
          top_signame: otp_ctrl_otp_macro
          index: -1
        }
        {
          name: core_tl
          struct: tl
          package: tlul_pkg
          type: req_rsp
          act: rsp
          width: 1
          inst_name: otp_ctrl
          default: ""
          end_idx: -1
          top_type: one-to-one
          top_signame: otp_ctrl_core_tl
          index: -1
        }
      ]
      generate_dif: true
    }
    {
      name: lc_ctrl
      type: lc_ctrl
      clock_srcs:
      {
        clk_i: io_div4
        clk_kmac_i: main
      }
      clock_group: secure
      reset_connections:
      {
        rst_ni:
        {
          name: lc_io_div4
          domain: Main
        }
        rst_kmac_ni:
        {
          name: lc
          domain: Main
        }
      }
      base_addrs:
      {
        regs:
        {
          hart: 0x40140000
        }
      }
      param_decl:
      {
        SecVolatileRawUnlockEn: top_pkg::SecVolatileRawUnlockEn
        SiliconCreatorId: 16'h 4001
        ProductId: 16'h 0010
        RevisionId: 8'h 01
        IdcodeValue: jtag_id_pkg::LC_CTRL_JTAG_IDCODE
        EscNumSeverities: AlertHandlerEscNumSeverities
        EscPingCountWidth: AlertHandlerEscPingCountWidth
      }
      domain: Main
      clock_connections:
      {
        clk_i: clkmgr_clocks_i.clk_io_div4_secure
        clk_kmac_i: clkmgr_clocks_i.clk_main_secure
      }
      memory: {}
      param_list:
      [
        {
          name: SecVolatileRawUnlockEn
          desc:
            '''
            Disable (0) or enable (1) volatile RAW UNLOCK capability.
            If enabled, it is possible to perform a volatile RAW -> TEST_UNLOCKED0 transition
            without programming the OTP. This is a useful fallback mode in case the OTP is
            not working correctly.

            IMPORTANT NOTE: This should only be used in test chips. The parameter must be set
            to 0 in production tapeouts since this weakens the security posture of the RAW
            UNLOCK mechanism.
            '''
          type: bit
          default: top_pkg::SecVolatileRawUnlockEn
          local: "false"
          expose: "true"
          name_top: SecLcCtrlVolatileRawUnlockEn
        }
        {
          name: UseDmiInterface
          desc: When 1, a TLUL-based DMI interface is used. When 0, a JTAG TAP is used.
          type: bit
          default: "0"
          local: "false"
          expose: "true"
          name_top: LcCtrlUseDmiInterface
        }
        {
          name: SiliconCreatorId
          desc: Chip generation number.
          type: logic [15:0]
          default: 16'h 4001
          local: "false"
          expose: "true"
          name_top: LcCtrlSiliconCreatorId
        }
        {
          name: ProductId
          desc: Chip revision number.
          type: logic [15:0]
          default: 16'h 0010
          local: "false"
          expose: "true"
          name_top: LcCtrlProductId
        }
        {
          name: RevisionId
          desc: Chip revision number.
          type: logic [7:0]
          default: 8'h 01
          local: "false"
          expose: "true"
          name_top: LcCtrlRevisionId
        }
        {
          name: IdcodeValue
          desc: JTAG ID code.
          type: logic [31:0]
          default: jtag_id_pkg::LC_CTRL_JTAG_IDCODE
          local: "false"
          expose: "true"
          name_top: LcCtrlIdcodeValue
        }
        {
          name: NumRmaAckSigs
          desc: Number of NVM RMA wiping response signals
          type: int
          default: "2"
          local: "true"
          expose: "true"
          name_top: LcCtrlNumRmaAckSigs
        }
        {
          name: EscNumSeverities
          desc: Number of escalation severities
          type: int
          default: AlertHandlerEscNumSeverities
          local: "false"
          expose: "false"
          name_top: LcCtrlEscNumSeverities
        }
        {
          name: EscPingCountWidth
          desc: Width of ping count for the escalation receiver
          type: int
          default: AlertHandlerEscPingCountWidth
          local: "false"
          expose: "false"
          name_top: LcCtrlEscPingCountWidth
        }
      ]
      inter_signal_list:
      [
        {
          name: jtag
          struct: jtag
          package: jtag_pkg
          type: req_rsp
          act: rsp
          width: 1
          inst_name: lc_ctrl
          default: ""
          domain: Main
          top_signame: pinmux_lc_jtag
          index: -1
          external: true
          conn_type: false
        }
        {
          name: esc_scrap_state0_tx
          struct: esc_tx
          package: prim_esc_pkg
          type: uni
          act: rcv
          width: 1
          inst_name: lc_ctrl
          default: ""
          domain: Main
          top_signame: alert_handler_esc_tx
          index: 1
        }
        {
          name: esc_scrap_state0_rx
          struct: esc_rx
          package: prim_esc_pkg
          type: uni
          act: req
          width: 1
          inst_name: lc_ctrl
          default: ""
          domain: Main
          top_signame: alert_handler_esc_rx
          index: 1
        }
        {
          name: esc_scrap_state1_tx
          struct: esc_tx
          package: prim_esc_pkg
          type: uni
          act: rcv
          width: 1
          inst_name: lc_ctrl
          default: ""
          domain: Main
          top_signame: alert_handler_esc_tx
          index: 2
        }
        {
          name: esc_scrap_state1_rx
          struct: esc_rx
          package: prim_esc_pkg
          type: uni
          act: req
          width: 1
          inst_name: lc_ctrl
          default: ""
          domain: Main
          top_signame: alert_handler_esc_rx
          index: 2
        }
        {
          name: pwr_lc
          struct: pwr_lc
          package: lc_ctrl_pkg
          type: req_rsp
          act: rsp
          width: 1
          inst_name: lc_ctrl
          default: ""
          domain: Main
          top_signame: pwrmgr_pwr_lc
          index: -1
          external: true
          conn_type: false
        }
        {
          name: lc_otp_vendor_test
          struct: otp_test
          package: otp_macro_pkg
          type: req_rsp
          act: req
          width: 1
          default: "'0"
          inst_name: lc_ctrl
          index: -1
        }
        {
          name: otp_lc_data
          struct: otp_lc_data
          package: otp_ctrl_pkg
          type: uni
          act: rcv
          width: 1
          default: otp_ctrl_pkg::OTP_LC_DATA_DEFAULT
          inst_name: lc_ctrl
          domain: Main
          top_signame: otp_ctrl_otp_lc_data
          index: -1
        }
        {
          name: lc_otp_program
          struct: lc_otp_program
          package: otp_ctrl_pkg
          type: req_rsp
          act: req
          width: 1
          default: "'0"
          inst_name: lc_ctrl
          end_idx: -1
          top_type: one-to-one
          top_signame: lc_ctrl_lc_otp_program
          index: -1
        }
        {
          name: kmac_data
          struct: app
          package: kmac_pkg
          type: req_rsp
          act: req
          width: 1
          default: "'0"
          inst_name: lc_ctrl
          domain: Main
          top_signame: kmac_app
          index: 1
        }
        {
          name: lc_init_done
          desc:
            '''
            Indicates that life cycle initialization is complete and the broadcast signals are valid; see `INIT_DONE` in the Theory of Operation doc for details.
            This signal is Off while lc_ctrl is in reset.
            Once On, it stays On until lc_ctrl is reset.
            '''
          struct: lc_tx
          package: lc_ctrl_pkg
          type: uni
          act: req
          width: 1
          default: lc_ctrl_pkg::Off
          inst_name: lc_ctrl
          end_idx: -1
          top_type: broadcast
          top_signame: lc_ctrl_lc_init_done
          index: -1
        }
        {
          name: lc_raw_test_rma
          struct: lc_tx
          package: lc_ctrl_pkg
          type: uni
          act: req
          width: 1
          default: lc_ctrl_pkg::Off
          inst_name: lc_ctrl
          index: -1
        }
        {
          name: lc_dft_en
          struct: lc_tx
          package: lc_ctrl_pkg
          type: uni
          act: req
          width: 1
          default: lc_ctrl_pkg::Off
          inst_name: lc_ctrl
          end_idx: -1
          top_type: broadcast
          top_signame: lc_ctrl_lc_dft_en
          index: -1
          external: true
          conn_type: true
        }
        {
          name: lc_nvm_debug_en
          struct: lc_tx
          package: lc_ctrl_pkg
          type: uni
          act: req
          width: 1
          default: lc_ctrl_pkg::Off
          inst_name: lc_ctrl
          end_idx: -1
          top_type: broadcast
          top_signame: lc_ctrl_lc_nvm_debug_en
          index: -1
          external: true
          conn_type: true
        }
        {
          name: lc_hw_debug_clr
          desc:
            '''
            Clear HW debug functionality; see `HW_DEBUG_CLR` in the Theory of Operation doc for details.

            This signal is used to clear stored copies of `lc_hw_debug_en` when HW debug functionality gets disabled outside a reset of `lc_ctrl`.
            This signal is On in the SCRAP, INVALID, POST_TRANSITION and ESCALATION states, in which `lc_hw_debug_en` is Off.
            Once On, it remains On until lc_ctrl is reset.
            Flops storing the value of `lc_hw_debug_en` (see below) must be cleared whenever this signal is not Off.
            '''
          struct: lc_tx
          package: lc_ctrl_pkg
          type: uni
          act: req
          width: 1
          default: lc_ctrl_pkg::Off
          inst_name: lc_ctrl
          end_idx: -1
          top_type: broadcast
          top_signame: lc_ctrl_lc_hw_debug_clr
          index: -1
          external: true
          conn_type: true
        }
        {
          name: lc_hw_debug_en
          desc:
            '''
            Enable HW debug functionality; see `HW_DEBUG_EN` in the Theory of Operation doc for details.

            This signal is Off while lc_ctrl is in reset.
            In order to prevent a JTAG disconnect during non-debug-module (NDM) reset, this signal should be flopped outside the NDM reset domain.
            Such a flop must be cleared whenever `lc_hw_debug_clr` is not Off; see above.
            '''
          struct: lc_tx
          package: lc_ctrl_pkg
          type: uni
          act: req
          width: 1
          default: lc_ctrl_pkg::Off
          inst_name: lc_ctrl
          end_idx: -1
          top_type: broadcast
          top_signame: lc_ctrl_lc_hw_debug_en
          index: -1
          external: true
          conn_type: true
        }
        {
          name: lc_cpu_en
          struct: lc_tx
          package: lc_ctrl_pkg
          type: uni
          act: req
          width: 1
          default: lc_ctrl_pkg::Off
          inst_name: lc_ctrl
          end_idx: -1
          top_type: broadcast
          top_signame: lc_ctrl_lc_cpu_en
          index: -1
        }
        {
          name: lc_keymgr_en
          struct: lc_tx
          package: lc_ctrl_pkg
          type: uni
          act: req
          width: 1
          default: lc_ctrl_pkg::Off
          inst_name: lc_ctrl
          end_idx: -1
          top_type: broadcast
          top_signame: lc_ctrl_lc_keymgr_en
          index: -1
        }
        {
          name: lc_escalate_en
          struct: lc_tx
          package: lc_ctrl_pkg
          type: uni
          act: req
          width: 1
          default: lc_ctrl_pkg::Off
          inst_name: lc_ctrl
          end_idx: -1
          top_type: broadcast
          top_signame: lc_ctrl_lc_escalate_en
          index: -1
          external: true
          conn_type: true
        }
        {
          name: lc_clk_byp_req
          struct: lc_tx
          package: lc_ctrl_pkg
          type: uni
          act: req
          width: 1
          default: lc_ctrl_pkg::Off
          inst_name: lc_ctrl
          end_idx: -1
          top_type: broadcast
          top_signame: lc_ctrl_lc_clk_byp_req
          index: -1
          external: true
          conn_type: false
        }
        {
          name: lc_clk_byp_ack
          struct: lc_tx
          package: lc_ctrl_pkg
          type: uni
          act: rcv
          width: 1
          default: lc_ctrl_pkg::Off
          inst_name: lc_ctrl
          end_idx: -1
          top_type: broadcast
          top_signame: lc_ctrl_lc_clk_byp_ack
          index: -1
          external: true
          conn_type: false
        }
        {
          name: lc_nvm_rma_req
          struct: lc_tx
          package: lc_ctrl_pkg
          type: uni
          act: req
          width: 1
          default: lc_ctrl_pkg::Off
          inst_name: lc_ctrl
          end_idx: -1
          top_type: broadcast
          top_signame: lc_ctrl_lc_nvm_rma_req
          index: -1
        }
        {
          name: lc_nvm_rma_ack
          struct: lc_tx
          package: lc_ctrl_pkg
          type: uni
          act: rcv
          width: 2
          default: lc_ctrl_pkg::On
          inst_name: lc_ctrl
          end_idx: -1
          top_type: one-to-N
          top_signame: lc_ctrl_lc_nvm_rma_ack
          index: -1
        }
        {
          name: lc_nvm_rma_seed
          struct: lc_nvm_rma_seed
          package: lc_ctrl_pkg
          type: uni
          act: req
          width: 1
          default: "'0"
          inst_name: lc_ctrl
          end_idx: -1
          top_type: broadcast
          top_signame: lc_ctrl_lc_nvm_rma_seed
          index: -1
        }
        {
          name: lc_check_byp_en
          struct: lc_tx
          package: lc_ctrl_pkg
          type: uni
          act: req
          width: 1
          default: lc_ctrl_pkg::Off
          inst_name: lc_ctrl
          end_idx: -1
          top_type: broadcast
          top_signame: lc_ctrl_lc_check_byp_en
          index: -1
          external: true
          conn_type: true
        }
        {
          name: lc_creator_seed_sw_rw_en
          struct: lc_tx
          package: lc_ctrl_pkg
          type: uni
          act: req
          width: 1
          default: lc_ctrl_pkg::Off
          inst_name: lc_ctrl
          end_idx: -1
          top_type: broadcast
          top_signame: lc_ctrl_lc_creator_seed_sw_rw_en
          index: -1
        }
        {
          name: lc_owner_seed_sw_rw_en
          struct: lc_tx
          package: lc_ctrl_pkg
          type: uni
          act: req
          width: 1
          default: lc_ctrl_pkg::Off
          inst_name: lc_ctrl
          end_idx: -1
          top_type: broadcast
          top_signame: lc_ctrl_lc_owner_seed_sw_rw_en
          index: -1
        }
        {
          name: lc_iso_part_sw_rd_en
          struct: lc_tx
          package: lc_ctrl_pkg
          type: uni
          act: req
          width: 1
          default: lc_ctrl_pkg::Off
          inst_name: lc_ctrl
          end_idx: -1
          top_type: broadcast
          top_signame: lc_ctrl_lc_iso_part_sw_rd_en
          index: -1
        }
        {
          name: lc_iso_part_sw_wr_en
          struct: lc_tx
          package: lc_ctrl_pkg
          type: uni
          act: req
          width: 1
          default: lc_ctrl_pkg::Off
          inst_name: lc_ctrl
          end_idx: -1
          top_type: broadcast
          top_signame: lc_ctrl_lc_iso_part_sw_wr_en
          index: -1
        }
        {
          name: lc_seed_hw_rd_en
          struct: lc_tx
          package: lc_ctrl_pkg
          type: uni
          act: req
          width: 1
          default: lc_ctrl_pkg::Off
          inst_name: lc_ctrl
          end_idx: -1
          top_type: broadcast
          top_signame: lc_ctrl_lc_seed_hw_rd_en
          index: -1
        }
        {
          name: lc_rma_state
          struct: lc_tx
          package: lc_ctrl_pkg
          type: uni
          act: req
          width: 1
          default: lc_ctrl_pkg::Off
          inst_name: lc_ctrl
          end_idx: -1
          top_type: broadcast
          top_signame: lc_ctrl_lc_rma_state
          index: -1
        }
        {
          name: lc_keymgr_div
          struct: lc_keymgr_div
          package: lc_ctrl_pkg
          type: uni
          act: req
          width: 1
          default: "'0"
          inst_name: lc_ctrl
          end_idx: -1
          top_type: broadcast
          top_signame: lc_ctrl_lc_keymgr_div
          index: -1
        }
        {
          name: otp_device_id
          struct: otp_device_id
          package: otp_ctrl_pkg
          type: uni
          act: rcv
          width: 1
          default: "'0"
          inst_name: lc_ctrl
          top_signame: lc_ctrl_otp_device_id
          index: -1
        }
        {
          name: otp_manuf_state
          struct: otp_manuf_state
          package: otp_ctrl_pkg
          type: uni
          act: rcv
          width: 1
          default: "'0"
          inst_name: lc_ctrl
          top_signame: lc_ctrl_otp_manuf_state
          index: -1
        }
        {
          name: hw_rev
          struct: lc_hw_rev
          package: lc_ctrl_pkg
          type: uni
          act: req
          width: 1
          default: "'0"
          inst_name: lc_ctrl
          index: -1
        }
        {
          name: strap_en_override
          desc:
            '''
            This signal transitions from 0 -> 1 by the lc_ctrl manager after volatile RAW_UNLOCK in order to re-sample the HW straps.
            The signal stays at 1 until reset.
            Note that this is only used in test chips when SecVolatileRawUnlockEn = 1.
            Otherwise this signal is tied off to 0.
            '''
          struct: logic
          type: uni
          act: req
          width: 1
          default: 1'b0
          inst_name: lc_ctrl
          package: ""
          end_idx: -1
          top_type: broadcast
          top_signame: lc_ctrl_strap_en_override
          index: -1
          external: true
          conn_type: false
        }
        {
          name: regs_tl
          struct: tl
          package: tlul_pkg
          type: req_rsp
          act: rsp
          width: 1
          inst_name: lc_ctrl
          default: ""
          end_idx: -1
          top_type: one-to-one
          top_signame: lc_ctrl_regs_tl
          index: -1
        }
        {
          name: dmi_tl
          struct: tl
          package: tlul_pkg
          type: req_rsp
          act: rsp
          width: 1
          inst_name: lc_ctrl
          index: -1
        }
      ]
      generate_dif: true
    }
    {
      name: alert_handler
      type: alert_handler
      template_type: alert_handler
      clock_srcs:
      {
        clk_i: io_div4
        clk_edn_i: main
      }
      clock_group: secure
      reset_connections:
      {
        rst_ni:
        {
          name: lc_io_div4
          domain: Main
        }
        rst_edn_ni:
        {
          name: lc
          domain: Main
        }
      }
      param_decl:
      {
        EscNumSeverities: "4"
        EscPingCountWidth: "16"
      }
      attr: ipgen
      domain: Main
      clock_connections:
      {
        clk_i: clkmgr_clocks_i.clk_io_div4_secure
        clk_edn_i: clkmgr_clocks_i.clk_main_secure
      }
      memory: {}
      param_list:
      [
        {
          name: EscNumSeverities
          desc: Number of escalation severities as regular parameter
          type: int
          default: "4"
          local: "false"
          expose: "true"
          name_top: AlertHandlerEscNumSeverities
        }
        {
          name: EscPingCountWidth
          desc: Width of ping counter as regular parameter
          type: int
          default: "16"
          local: "false"
          expose: "true"
          name_top: AlertHandlerEscPingCountWidth
        }
      ]
      inter_signal_list:
      [
        {
          name: crashdump
          struct: alert_crashdump
          package: alert_handler_pkg
          type: uni
          act: req
          width: 1
          inst_name: alert_handler
          default: ""
          end_idx: -1
          top_type: broadcast
          top_signame: alert_handler_crashdump
          index: -1
          external: true
          conn_type: false
        }
        {
          name: edn
          struct: edn
          package: edn_pkg
          type: req_rsp
          act: req
          width: 1
          inst_name: alert_handler
          default: ""
          domain: Main
          top_signame: edn0_edn
          index: 4
        }
        {
          name: esc_rx
          struct: esc_rx
          package: prim_esc_pkg
          type: uni
          act: rcv
          width: 4
          inst_name: alert_handler
          default: ""
          end_idx: -1
          top_type: one-to-N
          top_signame: alert_handler_esc_rx
          index: 3
          external: true
          conn_type: true
        }
        {
          name: esc_tx
          struct: esc_tx
          package: prim_esc_pkg
          type: uni
          act: req
          width: 4
          inst_name: alert_handler
          default: ""
          end_idx: -1
          top_type: one-to-N
          top_signame: alert_handler_esc_tx
          index: 3
          external: true
          conn_type: true
        }
        {
          name: tl
          struct: tl
          package: tlul_pkg
          type: req_rsp
          act: rsp
          width: 1
          inst_name: alert_handler
          default: ""
          end_idx: -1
          top_type: one-to-one
          top_signame: alert_handler_tl
          index: -1
        }
      ]
      base_addrs:
      {
        null:
        {
          hart: 0x40150000
        }
      }
      generate_dif: true
    }
    {
      name: spi_host0
      type: spi_host
      clock_srcs:
      {
        clk_i: io
      }
      clock_group: peri
      reset_connections:
      {
        rst_ni:
        {
          name: spi_host0
          domain: Main
        }
      }
      param_decl:
      {
        NumCS: "3"
      }
      domain: Main
      clock_connections:
      {
        clk_i: clkmgr_clocks_i.clk_io_peri
      }
      memory: {}
      param_list:
      [
        {
          name: NumCS
          desc: The number of active-low chip select (cs_n) lines to create.
          type: int
          default: "3"
          local: "true"
          expose: "true"
          name_top: SpiHost0NumCS
        }
      ]
      inter_signal_list:
      [
        {
          name: passthrough
          struct: passthrough
          package: spi_device_pkg
          type: req_rsp
          act: rsp
          width: 1
          inst_name: spi_host0
          default: ""
          domain: Main
          top_signame: spi_device_passthrough
          index: -1
        }
        {
          name: lsio_trigger
          desc:
            '''
            Self-clearing status trigger for the DMA.
            Set when RX or TX FIFOs are past their configured watermarks matching watermark interrupt behaviour.
            '''
          struct: logic
          type: uni
          act: req
          width: 1
          inst_name: spi_host0
          index: -1
        }
        {
          name: racl_policies
          desc:
            '''
            Incoming RACL policy vector from a racl_ctrl instance.
            The policy selection vector (parameter) selects the policy for each register.
            '''
          struct: racl_policy_vec
          package: top_racl_pkg
          type: uni
          act: rcv
          width: 1
          inst_name: spi_host0
          index: -1
        }
        {
          name: racl_error
          desc: RACL error log information of this module.
          struct: racl_error_log
          package: top_racl_pkg
          type: uni
          act: req
          width: 1
          inst_name: spi_host0
          index: -1
        }
        {
          name: tl
          struct: tl
          package: tlul_pkg
          type: req_rsp
          act: rsp
          width: 1
          inst_name: spi_host0
          default: ""
          end_idx: -1
          top_type: one-to-one
          top_signame: spi_host0_tl
          index: -1
        }
      ]
      base_addrs:
      {
        null:
        {
          hart: 0x40300000
        }
      }
      generate_dif: true
    }
    {
      name: spi_host1
      type: spi_host
      clock_srcs:
      {
        clk_i: io
      }
      clock_group: spi_host1
      reset_connections:
      {
        rst_ni:
        {
          name: spi_host1
          domain: Main
        }
      }
      param_decl:
      {
        NumCS: "3"
      }
      domain: Main
      clock_connections:
      {
        clk_i: clkmgr_clocks_i.clk_io_spi_host1
      }
      memory: {}
      param_list:
      [
        {
          name: NumCS
          desc: The number of active-low chip select (cs_n) lines to create.
          type: int
          default: "3"
          local: "true"
          expose: "true"
          name_top: SpiHost1NumCS
        }
      ]
      inter_signal_list:
      [
        {
          name: passthrough
          struct: passthrough
          package: spi_device_pkg
          type: req_rsp
          act: rsp
          width: 1
          inst_name: spi_host1
          index: -1
        }
        {
          name: lsio_trigger
          desc:
            '''
            Self-clearing status trigger for the DMA.
            Set when RX or TX FIFOs are past their configured watermarks matching watermark interrupt behaviour.
            '''
          struct: logic
          type: uni
          act: req
          width: 1
          inst_name: spi_host1
          index: -1
        }
        {
          name: racl_policies
          desc:
            '''
            Incoming RACL policy vector from a racl_ctrl instance.
            The policy selection vector (parameter) selects the policy for each register.
            '''
          struct: racl_policy_vec
          package: top_racl_pkg
          type: uni
          act: rcv
          width: 1
          inst_name: spi_host1
          index: -1
        }
        {
          name: racl_error
          desc: RACL error log information of this module.
          struct: racl_error_log
          package: top_racl_pkg
          type: uni
          act: req
          width: 1
          inst_name: spi_host1
          index: -1
        }
        {
          name: tl
          struct: tl
          package: tlul_pkg
          type: req_rsp
          act: rsp
          width: 1
          inst_name: spi_host1
          default: ""
          end_idx: -1
          top_type: one-to-one
          top_signame: spi_host1_tl
          index: -1
        }
      ]
      base_addrs:
      {
        null:
        {
          hart: 0x40310000
        }
      }
      generate_dif: true
    }
    {
      name: usbdev
      type: usbdev
      clock_srcs:
      {
        clk_i: usb
        clk_aon_i: aon
      }
      clock_group: peri
      reset_connections:
      {
        rst_ni:
        {
          name: usb
          domain: Main
        }
        rst_aon_ni:
        {
          name: usb_aon
          domain: Main
        }
      }
      param_decl:
      {
        RcvrWakeTimeUs: "100"
      }
      domain: Main
      clock_connections:
      {
        clk_i: clkmgr_clocks_i.clk_usb_peri
        clk_aon_i: clkmgr_clocks_i.clk_aon_peri
      }
      memory: {}
      param_list:
      [
        {
          name: Stub
          desc: Stub out the USB device logic, leaving only the register interface
          type: bit
          default: "0"
          local: "false"
          expose: "true"
          name_top: UsbdevStub
        }
        {
          name: RcvrWakeTimeUs
          desc: Maximum number of microseconds for the differential receiver to become operational
          type: int
          default: "100"
          local: "false"
          expose: "true"
          name_top: UsbdevRcvrWakeTimeUs
        }
      ]
      inter_signal_list:
      [
        {
          name: usb_rx_d
          desc: USB RX data from an external differential receiver, if available
          struct: logic
          type: uni
          act: rcv
          width: 1
          inst_name: usbdev
          default: ""
          package: ""
          external: true
          conn_type: false
          index: -1
          top_signame: usbdev_usb_rx_d
        }
        {
          name: usb_tx_d
          desc: USB transmit data value (not used if usb_tx_se0 is set)
          struct: logic
          type: uni
          act: req
          width: 1
          inst_name: usbdev
          default: ""
          package: ""
          external: true
          conn_type: false
          index: -1
          top_signame: usbdev_usb_tx_d
        }
        {
          name: usb_tx_se0
          desc: Force transmission of a USB single-ended zero (i.e. both D+ and D- are low) regardless of usb_tx_d
          struct: logic
          type: uni
          act: req
          width: 1
          inst_name: usbdev
          default: ""
          package: ""
          external: true
          conn_type: false
          index: -1
          top_signame: usbdev_usb_tx_se0
        }
        {
          name: usb_tx_use_d_se0
          desc: Use the usb_tx_d and usb_tx_se0 TX interface, instead of usb_dp_o and usb_dn_o
          struct: logic
          type: uni
          act: req
          width: 1
          inst_name: usbdev
          default: ""
          package: ""
          external: true
          conn_type: false
          index: -1
          top_signame: usbdev_usb_tx_use_d_se0
        }
        {
          name: usb_dp_pullup
          desc: USB D+ pullup control
          struct: logic
          type: uni
          act: req
          width: 1
          inst_name: usbdev
          default: ""
          package: ""
          end_idx: -1
          top_type: broadcast
          top_signame: usbdev_usb_dp_pullup
          index: -1
          external: true
          conn_type: false
        }
        {
          name: usb_dn_pullup
          desc: USB D- pullup control
          struct: logic
          type: uni
          act: req
          width: 1
          inst_name: usbdev
          default: ""
          package: ""
          end_idx: -1
          top_type: broadcast
          top_signame: usbdev_usb_dn_pullup
          index: -1
          external: true
          conn_type: false
        }
        {
          name: usb_rx_enable
          desc: USB differential receiver enable
          struct: logic
          type: uni
          act: req
          width: 1
          inst_name: usbdev
          default: ""
          package: ""
          external: true
          conn_type: false
          index: -1
          top_signame: usbdev_usb_rx_enable
        }
        {
          name: usb_ref_val
          desc: This indicates that USB timing reference signal 'usb_ref_pulse' is valid
          struct: logic
          type: uni
          act: req
          width: 1
          inst_name: usbdev
          default: ""
          package: ""
          end_idx: -1
          top_type: broadcast
          top_signame: usbdev_usb_ref_val
          index: -1
        }
        {
          name: usb_ref_pulse
          desc: USB timing reference signal. This signal pulses for a single 48MHz clock every 1ms USB frame
          struct: logic
          type: uni
          act: req
          width: 1
          inst_name: usbdev
          default: ""
          package: ""
          end_idx: -1
          top_type: broadcast
          top_signame: usbdev_usb_ref_pulse
          index: -1
        }
        {
          name: usb_aon_suspend_req
          desc: Request to activate the AON/Wake module and take control of the USB pullups
          struct: logic
          type: uni
          act: req
          width: 1
          inst_name: usbdev
          default: ""
          package: ""
          end_idx: -1
          top_type: broadcast
          top_signame: usbdev_usb_aon_suspend_req
          index: -1
          external: true
          conn_type: false
        }
        {
          name: usb_aon_wake_ack
          desc: Acknowledge a wake signal from the AON/Wake and relinquish control of the USB pullups
          struct: logic
          type: uni
          act: req
          width: 1
          inst_name: usbdev
          default: ""
          package: ""
          end_idx: -1
          top_type: broadcast
          top_signame: usbdev_usb_aon_wake_ack
          index: -1
          external: true
          conn_type: false
        }
        {
          name: usb_aon_bus_reset
          desc: Indicates that the reason for waking was that a USB Bus Reset occurred
          struct: logic
          type: uni
          act: rcv
          width: 1
          inst_name: usbdev
          default: ""
          package: ""
          end_idx: -1
          top_type: broadcast
          top_signame: usbdev_usb_aon_bus_reset
          index: -1
          external: true
          conn_type: false
        }
        {
          name: usb_aon_sense_lost
          desc: Indicates that the reason for waking was that the VBUS/SENSE signal became deasserted
          struct: logic
          type: uni
          act: rcv
          width: 1
          inst_name: usbdev
          default: ""
          package: ""
          end_idx: -1
          top_type: broadcast
          top_signame: usbdev_usb_aon_sense_lost
          index: -1
          external: true
          conn_type: false
        }
        {
          name: usb_aon_bus_not_idle
          desc: Indicates that the reason for waking was that the USB is in a non-idle state
          struct: logic
          type: uni
          act: rcv
          width: 1
          inst_name: usbdev
          default: ""
          package: ""
          end_idx: -1
          top_type: broadcast
          top_signame: usbdev_usb_aon_bus_not_idle
          index: -1
          external: true
          conn_type: false
        }
        {
          name: usb_aon_wake_detect_active
          desc: Indicates that the external AON/Wake module is active and controlling the USB pullups
          struct: logic
          type: uni
          act: rcv
          width: 1
          inst_name: usbdev
          default: ""
          package: ""
          domain: Main
          top_signame: pinmux_usbdev_wake_detect_active
          index: -1
          external: true
          conn_type: false
        }
        {
          name: ram_cfg
          struct: ram_1p_cfg
          package: prim_ram_1p_pkg
          type: req_rsp
          act: rsp
          width: 1
          inst_name: usbdev
          default: ""
          top_signame: usbdev_ram_cfg
          index: -1
        }
        {
          name: tl
          struct: tl
          package: tlul_pkg
          type: req_rsp
          act: rsp
          width: 1
          inst_name: usbdev
          default: ""
          end_idx: -1
          top_type: one-to-one
          top_signame: usbdev_tl
          index: -1
        }
      ]
      base_addrs:
      {
        null:
        {
          hart: 0x40320000
        }
      }
      generate_dif: true
    }
    {
      name: pwrmgr
      type: pwrmgr
      template_type: pwrmgr
      clock_group: powerup
      clock_srcs:
      {
        clk_i: io_div4
        clk_slow_i: aon
        clk_lc_i: io_div4
        clk_esc_i:
        {
          clock: io_div4
          group: secure
        }
      }
      reset_connections:
      {
        rst_ni:
        {
          name: por_io_div4
          domain: Aon
        }
        rst_main_ni:
        {
          name: por_aon
          domain: Main
        }
        rst_lc_ni:
        {
          name: lc_io_div4
          domain: Aon
        }
        rst_esc_ni:
        {
          name: lc_io_div4
          domain: Aon
        }
        rst_slow_ni:
        {
          name: por_aon
          domain: Aon
        }
      }
      domain: Aon
      param_decl:
      {
        EscNumSeverities: AlertHandlerEscNumSeverities
        EscPingCountWidth: AlertHandlerEscPingCountWidth
      }
      attr: ipgen
      clock_connections:
      {
        clk_i: clkmgr_clocks.clk_io_div4_powerup
        clk_slow_i: clkmgr_clocks.clk_aon_powerup
        clk_lc_i: clkmgr_clocks.clk_io_div4_powerup
        clk_esc_i: clkmgr_clocks.clk_io_div4_secure
      }
      memory: {}
      param_list:
      [
        {
          name: EscNumSeverities
          desc: Number of escalation severities
          type: int
          default: AlertHandlerEscNumSeverities
          local: "false"
          expose: "false"
          name_top: PwrmgrEscNumSeverities
        }
        {
          name: EscPingCountWidth
          desc: Width of ping count for the escalation receiver
          type: int
          default: AlertHandlerEscPingCountWidth
          local: "false"
          expose: "false"
          name_top: PwrmgrEscPingCountWidth
        }
      ]
      inter_signal_list:
      [
        {
          name: pwr_ast
          struct: pwr_ast
          package: pwrmgr_pkg
          type: req_rsp
          act: req
          width: 1
          inst_name: pwrmgr
          default: ""
          end_idx: -1
          top_type: one-to-one
          top_signame: pwrmgr_pwr_ast
          index: -1
        }
        {
          name: pwr_rst
          struct: pwr_rst
          package: pwrmgr_pkg
          type: req_rsp
          act: req
          width: 1
          inst_name: pwrmgr
          default: ""
          end_idx: -1
          top_type: one-to-one
          top_signame: pwrmgr_pwr_rst
          index: -1
        }
        {
          name: pwr_clk
          struct: pwr_clk
          package: pwrmgr_pkg
          type: req_rsp
          act: req
          width: 1
          inst_name: pwrmgr
          default: ""
          end_idx: -1
          top_type: one-to-one
          top_signame: pwrmgr_pwr_clk
          index: -1
        }
        {
          name: pwr_otp
          struct: pwr_otp
          package: pwrmgr_pkg
          type: req_rsp
          act: req
          width: 1
          inst_name: pwrmgr
          default: ""
          end_idx: -1
          top_type: one-to-one
          top_signame: pwrmgr_pwr_otp
          index: -1
          external: true
          conn_type: false
        }
        {
          name: pwr_lc
          struct: pwr_lc
          package: lc_ctrl_pkg
          type: req_rsp
          act: req
          width: 1
          inst_name: pwrmgr
          default: ""
          end_idx: -1
          top_type: one-to-one
          top_signame: pwrmgr_pwr_lc
          index: -1
          external: true
          conn_type: false
        }
        {
          name: pwr_nvm
          struct: pwr_nvm
          package: pwrmgr_pkg
          type: uni
          act: rcv
          width: 1
          inst_name: pwrmgr
          default: ""
          end_idx: -1
          top_type: broadcast
          top_signame: pwrmgr_pwr_nvm
          index: -1
          external: true
          conn_type: false
        }
        {
          name: esc_rst_tx
          struct: esc_tx
          package: prim_esc_pkg
          type: uni
          act: rcv
          width: 1
          inst_name: pwrmgr
          default: ""
          domain: Aon
          top_signame: alert_handler_esc_tx
          index: -1
          external: true
          conn_type: false
        }
        {
          name: esc_rst_rx
          struct: esc_rx
          package: prim_esc_pkg
          type: uni
          act: req
          width: 1
          inst_name: pwrmgr
          default: ""
          domain: Aon
          top_signame: alert_handler_esc_rx
          index: -1
          external: true
          conn_type: false
        }
        {
          name: pwr_cpu
          struct: cpu_pwrmgr
          package: rv_core_ibex_pkg
          type: uni
          act: rcv
          width: 1
          inst_name: pwrmgr
          default: ""
          domain: Aon
          top_signame: rv_core_ibex_pwrmgr
          index: -1
          external: true
          conn_type: false
        }
        {
          name: wakeups
          struct: logic
          type: uni
          act: rcv
          width: 8
          inst_name: pwrmgr
          default: ""
          package: ""
          end_idx: -1
          top_type: one-to-N
          top_signame: pwrmgr_wakeups
          index: 1
          external: true
          conn_type: true
        }
        {
          name: rstreqs
          struct: logic
          type: uni
          act: rcv
          width: 2
          inst_name: pwrmgr
          default: ""
          package: ""
          end_idx: -1
          top_type: one-to-N
          top_signame: pwrmgr_rstreqs
          index: -1
        }
        {
          name: ndmreset_req
          struct: logic
          type: uni
          act: rcv
          width: 1
          inst_name: pwrmgr
          default: ""
          package: ""
          domain: Aon
          top_signame: rv_dm_ndmreset_req
          index: -1
          external: true
          conn_type: false
        }
        {
          name: strap
          struct: logic
          type: uni
          act: req
          width: 1
          inst_name: pwrmgr
          default: ""
          package: ""
          end_idx: -1
          top_type: broadcast
          top_signame: pwrmgr_strap
          index: -1
        }
        {
          name: low_power
          struct: logic
          type: uni
          act: req
          width: 1
          inst_name: pwrmgr
          default: ""
          package: ""
          end_idx: -1
          top_type: broadcast
          top_signame: pwrmgr_low_power
          index: -1
        }
        {
          name: rom_ctrl
          struct: pwrmgr_data
          package: rom_ctrl_pkg
          type: uni
          act: rcv
          width: 1
          default: rom_ctrl_pkg::PWRMGR_DATA_DEFAULT
          inst_name: pwrmgr
          domain: Aon
          top_signame: rom_ctrl_pwrmgr_data
          index: -1
          external: true
          conn_type: false
        }
        {
          name: fetch_en
          struct: lc_tx
          package: lc_ctrl_pkg
          type: uni
          act: req
          width: 1
          inst_name: pwrmgr
          default: ""
          end_idx: -1
          top_type: broadcast
          top_signame: pwrmgr_fetch_en
          index: -1
          external: true
          conn_type: false
        }
        {
          name: lc_dft_en
          struct: lc_tx
          package: lc_ctrl_pkg
          type: uni
          act: rcv
          width: 1
          inst_name: pwrmgr
          default: ""
          domain: Aon
          top_signame: lc_ctrl_lc_dft_en
          index: -1
          external: true
          conn_type: false
        }
        {
          name: lc_hw_debug_en
          struct: lc_tx
          package: lc_ctrl_pkg
          type: uni
          act: rcv
          width: 1
          inst_name: pwrmgr
          default: ""
          domain: Aon
          top_signame: lc_ctrl_lc_hw_debug_en
          index: -1
          external: true
          conn_type: false
        }
        {
          name: sw_rst_req
          struct: mubi4
          package: prim_mubi_pkg
          type: uni
          act: rcv
          width: 1
          inst_name: pwrmgr
          default: ""
          domain: Aon
          top_signame: rstmgr_sw_rst_req
          index: -1
        }
        {
          name: tl
          struct: tl
          package: tlul_pkg
          type: req_rsp
          act: rsp
          width: 1
          inst_name: pwrmgr
          default: ""
          end_idx: -1
          top_type: one-to-one
          top_signame: pwrmgr_tl
          index: -1
          external: true
          conn_type: false
        }
      ]
      base_addrs:
      {
        null:
        {
          hart: 0x40400000
        }
      }
      generate_dif: true
    }
    {
      name: rstmgr
      type: rstmgr
      template_type: rstmgr
      clock_srcs:
      {
        clk_i:
        {
          clock: io_div4
          group: powerup
        }
        clk_por_i: io_div4
        clk_aon_i: aon
        clk_main_i: main
        clk_io_i: io
        clk_usb_i: usb
        clk_io_div4_i: io_div4
      }
      clock_group: powerup
      reset_connections:
      {
        rst_ni:
        {
          name: lc_io_div4
          domain: Aon
        }
        rst_por_ni:
        {
          name: por_io_div4
          domain: Aon
        }
      }
      domain: Aon
      attr: ipgen
      clock_connections:
      {
        clk_i: clkmgr_clocks.clk_io_div4_powerup
        clk_por_i: clkmgr_clocks.clk_io_div4_powerup
        clk_aon_i: clkmgr_clocks.clk_aon_powerup
        clk_main_i: clkmgr_clocks.clk_main_powerup
        clk_io_i: clkmgr_clocks.clk_io_powerup
        clk_usb_i: clkmgr_clocks.clk_usb_powerup
        clk_io_div4_i: clkmgr_clocks.clk_io_div4_powerup
      }
      param_decl: {}
      memory: {}
      param_list:
      [
        {
          name: SecCheck
          desc:
            '''
            When 1, enable rstmgr reset consistency checks.
            When 0, there are no consistency checks.
            '''
          type: bit
          default: 1'b1
          local: "false"
          expose: "true"
          name_top: SecRstmgrCheck
        }
        {
          name: SecMaxSyncDelay
          desc: The maximum synchronization delay for parent / child reset checks.
          type: int
          default: "2"
          local: "false"
          expose: "true"
          name_top: SecRstmgrMaxSyncDelay
        }
      ]
      inter_signal_list:
      [
        {
          name: por_n
          desc:
            '''
            Root power on reset signals from ast.
            There is one root reset signal for each core power domain.
            '''
          struct: logic
          type: uni
          act: rcv
          width: 2
          inst_name: rstmgr
          default: ""
          package: ""
          end_idx: -1
          top_type: broadcast
          top_signame: rstmgr_por_n
          index: -1
        }
        {
          name: pwr
          desc:
            '''
            Reset request signals from power manager.
            Power manager can request for specific domains of the lc/sys reset tree to assert.
            '''
          struct: pwr_rst
          type: req_rsp
          act: rsp
          width: 1
          inst_name: rstmgr
          default: ""
          package: pwrmgr_pkg
          domain: Aon
          top_signame: pwrmgr_pwr_rst
          index: -1
        }
        {
          name: resets
          desc: Leaf resets fed to the system.
          struct: rstmgr_out
          package: rstmgr_pkg
          type: uni
          act: req
          width: 1
          inst_name: rstmgr
          default: ""
          domain: Aon
          top_signame: rstmgr_resets
          index: -1
        }
        {
          name: rst_en
          desc: Low-power-group outputs used by alert handler.
          struct: rstmgr_rst_en
          package: rstmgr_pkg
          type: uni
          act: req
          width: 1
          inst_name: rstmgr
          default: ""
          top_signame: rstmgr_rst_en
          index: -1
        }
        {
          name: alert_dump
          desc: Alert handler crash dump information.
          struct: alert_crashdump
          package: alert_handler_pkg
          type: uni
          act: rcv
          width: 1
          inst_name: rstmgr
          default: ""
          domain: Aon
          top_signame: alert_handler_crashdump
          index: -1
          external: true
          conn_type: false
        }
        {
          name: cpu_dump
          desc: Main processing element crash dump information.
          struct: cpu_crash_dump
          package: rv_core_ibex_pkg
          type: uni
          act: rcv
          width: 1
          inst_name: rstmgr
          default: ""
          domain: Aon
          top_signame: rv_core_ibex_crash_dump
          index: -1
          external: true
          conn_type: false
        }
        {
          name: sw_rst_req
          desc: Software requested system reset to pwrmgr.
          struct: mubi4
          package: prim_mubi_pkg
          type: uni
          act: req
          width: 1
          inst_name: rstmgr
          default: ""
          end_idx: -1
          top_type: broadcast
          top_signame: rstmgr_sw_rst_req
          index: -1
        }
        {
          name: tl
          struct: tl
          package: tlul_pkg
          type: req_rsp
          act: rsp
          width: 1
          inst_name: rstmgr
          default: ""
          end_idx: -1
          top_type: one-to-one
          top_signame: rstmgr_tl
          index: -1
          external: true
          conn_type: false
        }
      ]
      base_addrs:
      {
        null:
        {
          hart: 0x40410000
        }
      }
      generate_dif: true
    }
    {
      name: clkmgr
      type: clkmgr
      template_type: clkmgr
      clock_srcs:
      {
        clk_i: io_div4
        clk_main_i:
        {
          group: ast
          clock: main
        }
        clk_io_i:
        {
          group: ast
          clock: io
        }
        clk_usb_i:
        {
          group: ast
          clock: usb
        }
        clk_aon_i:
        {
          group: ast
          clock: aon
        }
      }
      clock_group: powerup
      reset_connections:
      {
        rst_ni:
        {
          name: lc_io_div4
          domain: Aon
        }
        rst_aon_ni:
        {
          name: lc_aon
          domain: Aon
        }
        rst_io_ni:
        {
          name: lc_io
          domain: Aon
        }
        rst_io_div4_ni:
        {
          name: lc_io_div4
          domain: Aon
        }
        rst_main_ni:
        {
          name: lc
          domain: Aon
        }
        rst_usb_ni:
        {
          name: lc_usb
          domain: Aon
        }
        rst_root_ni:
        {
          name: por_io_div4
          domain: Aon
        }
        rst_root_io_ni:
        {
          name: por_io
          domain: Aon
        }
        rst_root_io_div4_ni:
        {
          name: por_io_div4
          domain: Aon
        }
        rst_root_main_ni:
        {
          name: por
          domain: Aon
        }
        rst_root_usb_ni:
        {
          name: por_usb
          domain: Aon
        }
      }
      domain: Aon
      attr: ipgen
      clock_connections:
      {
        clk_i: clkmgr_clocks.clk_io_div4_powerup
        clk_main_i: ast_clk_src_sys_i
        clk_io_i: ast_clk_src_io_i
        clk_usb_i: ast_clk_src_usb_i
        clk_aon_i: ast_clk_src_aon
      }
      param_decl: {}
      memory: {}
      param_list: []
      inter_signal_list:
      [
        {
          name: clocks
          struct: clkmgr_out
          package: clkmgr_pkg
          type: uni
          act: req
          width: 1
          inst_name: clkmgr
          default: ""
          domain: Aon
          top_signame: clkmgr_clocks
          index: -1
        }
        {
          name: cg_en
          struct: clkmgr_cg_en
          package: clkmgr_pkg
          type: uni
          act: req
          width: 1
          inst_name: clkmgr
          default: ""
          top_signame: clkmgr_cg_en
          index: -1
        }
        {
          name: lc_hw_debug_en
          struct: lc_tx
          package: lc_ctrl_pkg
          type: uni
          act: rcv
          width: 1
          inst_name: clkmgr
          default: ""
          domain: Aon
          top_signame: lc_ctrl_lc_hw_debug_en
          index: -1
          external: true
          conn_type: false
        }
        {
          name: io_clk_byp_req
          struct: mubi4
          package: prim_mubi_pkg
          type: uni
          act: req
          width: 1
          inst_name: clkmgr
          default: ""
          end_idx: -1
          top_type: broadcast
          top_signame: clkmgr_io_clk_byp_req
          index: -1
          external: true
          conn_type: false
        }
        {
          name: io_clk_byp_ack
          struct: mubi4
          package: prim_mubi_pkg
          type: uni
          act: rcv
          width: 1
          inst_name: clkmgr
          default: ""
          end_idx: -1
          top_type: broadcast
          top_signame: clkmgr_io_clk_byp_ack
          index: -1
          external: true
          conn_type: false
        }
        {
          name: all_clk_byp_req
          struct: mubi4
          package: prim_mubi_pkg
          type: uni
          act: req
          width: 1
          inst_name: clkmgr
          default: ""
          end_idx: -1
          top_type: broadcast
          top_signame: clkmgr_all_clk_byp_req
          index: -1
          external: true
          conn_type: false
        }
        {
          name: all_clk_byp_ack
          struct: mubi4
          package: prim_mubi_pkg
          type: uni
          act: rcv
          width: 1
          inst_name: clkmgr
          default: ""
          end_idx: -1
          top_type: broadcast
          top_signame: clkmgr_all_clk_byp_ack
          index: -1
          external: true
          conn_type: false
        }
        {
          name: hi_speed_sel
          struct: mubi4
          package: prim_mubi_pkg
          type: uni
          act: req
          width: 1
          inst_name: clkmgr
          default: ""
          end_idx: -1
          top_type: broadcast
          top_signame: clkmgr_hi_speed_sel
          index: -1
          external: true
          conn_type: false
        }
        {
          name: div_step_down_req
          struct: mubi4
          package: prim_mubi_pkg
          type: uni
          act: rcv
          width: 1
          inst_name: clkmgr
          default: ""
          end_idx: -1
          top_type: broadcast
          top_signame: clkmgr_div_step_down_req
          index: -1
          external: true
          conn_type: false
        }
        {
          name: lc_clk_byp_req
          struct: lc_tx
          package: lc_ctrl_pkg
          type: uni
          act: rcv
          width: 1
          inst_name: clkmgr
          default: ""
          domain: Aon
          top_signame: lc_ctrl_lc_clk_byp_req
          index: -1
          external: true
          conn_type: false
        }
        {
          name: lc_clk_byp_ack
          struct: lc_tx
          package: lc_ctrl_pkg
          type: uni
          act: req
          width: 1
          inst_name: clkmgr
          default: ""
          domain: Aon
          top_signame: lc_ctrl_lc_clk_byp_ack
          index: -1
          external: true
          conn_type: false
        }
        {
          name: jitter_en
          struct: mubi4
          package: prim_mubi_pkg
          type: uni
          act: req
          width: 1
          inst_name: clkmgr
          default: ""
          domain: Aon
          top_signame: ast_clk_src_sys_jen
          index: -1
          external: true
          conn_type: false
        }
        {
          name: pwr
          struct: pwr_clk
          type: req_rsp
          act: rsp
          width: 1
          inst_name: clkmgr
          default: ""
          package: pwrmgr_pkg
          domain: Aon
          top_signame: pwrmgr_pwr_clk
          index: -1
        }
        {
          name: idle
          struct: mubi4
          package: prim_mubi_pkg
          type: uni
          act: rcv
          width: 4
          inst_name: clkmgr
          default: ""
          end_idx: -1
          top_type: one-to-N
          top_signame: clkmgr_idle
          index: -1
          external: true
          conn_type: false
        }
        {
          name: calib_rdy
          desc: Indicates clocks are calibrated and frequencies accurate
          struct: mubi4
          package: prim_mubi_pkg
          type: uni
          act: rcv
          width: 1
          default: prim_mubi_pkg::MuBi4True
          inst_name: clkmgr
          domain: Aon
          top_signame: ast_init_done
          index: -1
          external: true
          conn_type: false
        }
        {
          name: tl
          struct: tl
          package: tlul_pkg
          type: req_rsp
          act: rsp
          width: 1
          inst_name: clkmgr
          default: ""
          end_idx: -1
          top_type: one-to-one
          top_signame: clkmgr_tl
          index: -1
          external: true
          conn_type: false
        }
      ]
      base_addrs:
      {
        null:
        {
          hart: 0x40420000
        }
      }
      generate_dif: true
    }
    {
      name: sysrst_ctrl
      type: sysrst_ctrl
      clock_srcs:
      {
        clk_i: io_div4
        clk_aon_i: aon
      }
      clock_group: secure
      reset_connections:
      {
        rst_ni:
        {
          name: lc_io_div4
          domain: Aon
        }
        rst_aon_ni:
        {
          name: lc_aon
          domain: Aon
        }
      }
      domain: Aon
      clock_connections:
      {
        clk_i: clkmgr_clocks.clk_io_div4_secure
        clk_aon_i: clkmgr_clocks.clk_aon_secure
      }
      param_decl: {}
      memory: {}
      param_list: []
      inter_signal_list:
      [
        {
          name: wkup_req
          struct: logic
          type: uni
          act: req
          width: 1
          inst_name: sysrst_ctrl
          default: ""
          package: ""
          domain: Aon
          top_signame: pwrmgr_wakeups
          index: 2
        }
        {
          name: rst_req
          struct: logic
          type: uni
          act: req
          width: 1
          inst_name: sysrst_ctrl
          default: ""
          package: ""
          domain: Aon
          top_signame: pwrmgr_rstreqs
          index: 0
        }
        {
          name: tl
          struct: tl
          package: tlul_pkg
          type: req_rsp
          act: rsp
          width: 1
          inst_name: sysrst_ctrl
          default: ""
          end_idx: -1
          top_type: one-to-one
          top_signame: sysrst_ctrl_tl
          index: -1
          external: true
          conn_type: false
        }
      ]
      base_addrs:
      {
        null:
        {
          hart: 0x40430000
        }
      }
      generate_dif: true
    }
    {
      name: adc_ctrl
      type: adc_ctrl
      clock_srcs:
      {
        clk_i: io_div4
        clk_aon_i: aon
      }
      clock_group: peri
      reset_connections:
      {
        rst_ni:
        {
          name: lc_io_div4
          domain: Aon
        }
        rst_aon_ni:
        {
          name: lc_aon
          domain: Aon
        }
      }
      domain: Aon
      clock_connections:
      {
        clk_i: clkmgr_clocks.clk_io_div4_peri
        clk_aon_i: clkmgr_clocks.clk_aon_peri
      }
      param_decl: {}
      memory: {}
      param_list: []
      inter_signal_list:
      [
        {
          name: adc
          struct: adc_ast
          package: ast_pkg
          type: req_rsp
          act: req
          width: 1
          inst_name: adc_ctrl
          default: ""
          domain: Aon
          top_signame: ast_adc
          index: -1
        }
        {
          name: wkup_req
          struct: logic
          type: uni
          act: req
          width: 1
          inst_name: adc_ctrl
          default: ""
          package: ""
          domain: Aon
          top_signame: pwrmgr_wakeups
          index: 3
        }
        {
          name: tl
          struct: tl
          package: tlul_pkg
          type: req_rsp
          act: rsp
          width: 1
          inst_name: adc_ctrl
          default: ""
          end_idx: -1
          top_type: one-to-one
          top_signame: adc_ctrl_tl
          index: -1
          external: true
          conn_type: false
        }
      ]
      base_addrs:
      {
        null:
        {
          hart: 0x40440000
        }
      }
      generate_dif: true
    }
    {
      name: pinmux
      type: pinmux
      template_type: pinmux
      clock_srcs:
      {
        clk_i: io_div4
        clk_aon_i: aon
      }
      clock_group: powerup
      reset_connections:
      {
        rst_ni:
        {
          name: lc_io_div4
          domain: Aon
        }
        rst_aon_ni:
        {
          name: lc_aon
          domain: Aon
        }
        rst_sys_ni:
        {
          name: sys_io_div4
          domain: Aon
        }
      }
      domain: Aon
      attr: ipgen
      param_decl:
      {
        SecVolatileRawUnlockEn: top_pkg::SecVolatileRawUnlockEn
      }
      clock_connections:
      {
        clk_i: clkmgr_clocks.clk_io_div4_powerup
        clk_aon_i: clkmgr_clocks.clk_aon_powerup
      }
      memory: {}
      param_list:
      [
        {
          name: SecVolatileRawUnlockEn
          desc:
            '''
            Disable (0) or enable (1) volatile RAW UNLOCK capability.
            If enabled, the strap_en_override_i input can be used to re-sample the straps at runtime.

            IMPORTANT NOTE: This should only be used in test chips. The parameter must be set
            to 0 in production tapeouts since this weakens the security posture of the RAW
            UNLOCK mechanism.
            '''
          type: bit
          default: top_pkg::SecVolatileRawUnlockEn
          local: "false"
          expose: "true"
          name_top: SecPinmuxVolatileRawUnlockEn
        }
        {
          name: TargetCfg
          desc: Target specific pinmux configuration.
          type: pinmux_pkg::target_cfg_t
          default: pinmux_pkg::DefaultTargetCfg
          local: "false"
          expose: "true"
          name_top: PinmuxTargetCfg
        }
      ]
      inter_signal_list:
      [
        {
          name: lc_hw_debug_clr
          desc: Debug clear signal coming from life cycle controller, used for HW strap qualification.
          struct: lc_tx
          package: lc_ctrl_pkg
          type: uni
          act: rcv
          width: 1
          default: lc_ctrl_pkg::Off
          inst_name: pinmux
          domain: Aon
          top_signame: lc_ctrl_lc_hw_debug_clr
          index: -1
          external: true
          conn_type: false
        }
        {
          name: lc_hw_debug_en
          desc: Debug enable qualifier coming from life cycle controller, used for HW strap qualification.
          struct: lc_tx
          package: lc_ctrl_pkg
          type: uni
          act: rcv
          width: 1
          default: lc_ctrl_pkg::Off
          inst_name: pinmux
          domain: Aon
          top_signame: lc_ctrl_lc_hw_debug_en
          index: -1
          external: true
          conn_type: false
        }
        {
          name: lc_dft_en
          desc: Test enable qualifier coming from life cycle controller, used for HW strap qualification.
          struct: lc_tx
          package: lc_ctrl_pkg
          type: uni
          act: rcv
          width: 1
          default: lc_ctrl_pkg::Off
          inst_name: pinmux
          domain: Aon
          top_signame: lc_ctrl_lc_dft_en
          index: -1
          external: true
          conn_type: false
        }
        {
          name: lc_nvm_debug_en
          desc:
            '''
            NVM debug enable coming from life cycle controller.
            The RRAM TAP can only be selected while this signal is On.
            '''
          struct: lc_tx
          package: lc_ctrl_pkg
          type: uni
          act: rcv
          width: 1
          default: lc_ctrl_pkg::Off
          inst_name: pinmux
          domain: Aon
          top_signame: lc_ctrl_lc_nvm_debug_en
          index: -1
          external: true
          conn_type: false
        }
        {
          name: lc_escalate_en
          desc:
            '''
            Escalation enable signal coming from life cycle controller, used for invalidating
            the latched lc_hw_debug_en state inside the strap sampling logic.
            '''
          struct: lc_tx
          package: lc_ctrl_pkg
          type: uni
          act: rcv
          width: 1
          default: lc_ctrl_pkg::Off
          inst_name: pinmux
          domain: Aon
          top_signame: lc_ctrl_lc_escalate_en
          index: -1
          external: true
          conn_type: false
        }
        {
          name: lc_check_byp_en
          desc:
            '''
            Check bypass enable signal coming from life cycle controller, used for invalidating
            the latched lc_hw_debug_en state inside the strap sampling logic. This signal is asserted
            whenever the life cycle controller performs a life cycle transition. Its main use is
            to skip any background checks inside the life cycle partition of the OTP controller while
            a life cycle transition is in progress.
            '''
          struct: lc_tx
          package: lc_ctrl_pkg
          type: uni
          act: rcv
          width: 1
          default: lc_ctrl_pkg::Off
          inst_name: pinmux
          domain: Aon
          top_signame: lc_ctrl_lc_check_byp_en
          index: -1
          external: true
          conn_type: false
        }
        {
          name: pinmux_hw_debug_en
          desc:
            '''
            This is the latched version of lc_hw_debug_en_i. We use it exclusively to gate the JTAG
            signals and TAP side of the RV_DM so that RV_DM can remain live during an NDM reset cycle.
            '''
          struct: lc_tx
          package: lc_ctrl_pkg
          type: uni
          act: req
          width: 1
          default: lc_ctrl_pkg::Off
          inst_name: pinmux
          end_idx: -1
          top_type: broadcast
          top_signame: pinmux_pinmux_hw_debug_en
          index: -1
          external: true
          conn_type: false
        }
        {
          name: lc_jtag
          desc: Qualified JTAG signals for life cycle controller TAP.
          struct: jtag
          package: jtag_pkg
          type: req_rsp
          act: req
          width: 1
          inst_name: pinmux
          default: ""
          end_idx: -1
          top_type: one-to-one
          top_signame: pinmux_lc_jtag
          index: -1
          external: true
          conn_type: false
        }
        {
          name: rv_jtag
          desc: Qualified JTAG signals for RISC-V processor TAP.
          struct: jtag
          package: jtag_pkg
          type: req_rsp
          act: req
          width: 1
          inst_name: pinmux
          default: ""
          end_idx: -1
          top_type: one-to-one
          top_signame: pinmux_rv_jtag
          index: -1
          external: true
          conn_type: false
        }
        {
          name: dft_jtag
          desc: Qualified JTAG signals for DFT TAP.
          struct: jtag
          package: jtag_pkg
          type: req_rsp
          act: req
          width: 1
          inst_name: pinmux
          default: ""
          top_signame: pinmux_dft_jtag
          index: -1
        }
        {
          name: rram_jtag
          desc: Qualified JTAG signals for the RRAM TAP.
          struct: jtag
          package: jtag_pkg
          type: req_rsp
          act: req
          width: 1
          inst_name: pinmux
          default: ""
          end_idx: -1
          top_type: one-to-one
          top_signame: pinmux_rram_jtag
          index: -1
          external: true
          conn_type: false
        }
        {
          name: dft_strap_test
          desc: Sampled DFT strap values, going to the DFT TAP.
          struct: dft_strap_test_req
          package: pinmux_pkg
          type: uni
          act: req
          width: 1
          default: "'0"
          inst_name: pinmux
          end_idx: -1
          top_type: broadcast
          top_signame: pinmux_dft_strap_test
          index: -1
        }
        {
          name: dft_hold_tap_sel
          desc: TAP selection hold indication, asserted by the DFT TAP during boundary scan.
          struct: logic
          type: uni
          act: rcv
          width: 1
          default: "'0"
          inst_name: pinmux
          package: ""
          external: true
          conn_type: false
          index: -1
          top_signame: dft_hold_tap_sel
        }
        {
          name: sleep_en
          desc: Level signal that is asserted when the power manager enters sleep.
          struct: logic
          type: uni
          act: rcv
          width: 1
          default: 1'b0
          inst_name: pinmux
          package: ""
          domain: Aon
          top_signame: pwrmgr_low_power
          index: -1
        }
        {
          name: strap_en
          desc: This signal is pulsed high by the power manager after reset in order to sample the HW straps.
          struct: logic
          type: uni
          act: rcv
          width: 1
          default: 1'b0
          inst_name: pinmux
          package: ""
          domain: Aon
          top_signame: pwrmgr_strap
          index: -1
        }
        {
          name: strap_en_override
          desc:
            '''
            This signal transitions from 0 -> 1 by the lc_ctrl manager after volatile RAW_UNLOCK in order to re-sample the HW straps.
            The signal must stay at 1 until reset.
            Note that this is only used in test chips when SecVolatileRawUnlockEn = 1.
            Otherwise this signal is unused.
            '''
          struct: logic
          type: uni
          act: rcv
          width: 1
          default: 1'b0
          inst_name: pinmux
          package: ""
          domain: Aon
          top_signame: lc_ctrl_strap_en_override
          index: -1
          external: true
          conn_type: false
        }
        {
          name: pin_wkup_req
          desc: Wakeup request from wakeup detectors, to the power manager, running on the AON clock.
          struct: logic
          type: uni
          act: req
          width: 1
          default: 1'b0
          inst_name: pinmux
          package: ""
          domain: Aon
          top_signame: pwrmgr_wakeups
          index: 4
        }
        {
          name: usbdev_dppullup_en
          desc: Pullup enable signal coming from the USB IP.
          struct: logic
          type: uni
          act: rcv
          width: 1
          inst_name: pinmux
          default: ""
          package: ""
          domain: Aon
          top_signame: usbdev_usb_dp_pullup
          index: -1
          external: true
          conn_type: false
        }
        {
          name: usbdev_dnpullup_en
          desc: Pullup enable signal coming from the USB IP.
          struct: logic
          type: uni
          act: rcv
          width: 1
          inst_name: pinmux
          default: ""
          package: ""
          domain: Aon
          top_signame: usbdev_usb_dn_pullup
          index: -1
          external: true
          conn_type: false
        }
        {
          name: usb_dppullup_en
          desc: " Pullup enable signal going to USB PHY, needs to be maintained in low-power mode."
          struct: logic
          type: uni
          act: req
          width: 1
          default: 1'b0
          inst_name: pinmux
          package: ""
          external: true
          conn_type: false
          index: -1
          top_signame: usb_dp_pullup_en
        }
        {
          name: usb_dnpullup_en
          desc: Pullup enable signal going to USB PHY, needs to be maintained in low-power mode.
          struct: logic
          type: uni
          act: req
          width: 1
          default: 1'b0
          inst_name: pinmux
          package: ""
          external: true
          conn_type: false
          index: -1
          top_signame: usb_dn_pullup_en
        }
        {
          name: usb_wkup_req
          desc: Wakeup request from USB wakeup detector, going to the power manager, running on the AON clock.
          struct: logic
          type: uni
          act: req
          width: 1
          default: 1'b0
          inst_name: pinmux
          package: ""
          domain: Aon
          top_signame: pwrmgr_wakeups
          index: 5
        }
        {
          name: usbdev_suspend_req
          desc: Indicates whether USB is in suspended state, coming from the USB device.
          struct: logic
          type: uni
          act: rcv
          width: 1
          inst_name: pinmux
          default: ""
          package: ""
          domain: Aon
          top_signame: usbdev_usb_aon_suspend_req
          index: -1
          external: true
          conn_type: false
        }
        {
          name: usbdev_wake_ack
          desc: Acknowledges the USB wakeup request, coming from the USB device.
          struct: logic
          type: uni
          act: rcv
          width: 1
          inst_name: pinmux
          default: ""
          package: ""
          domain: Aon
          top_signame: usbdev_usb_aon_wake_ack
          index: -1
          external: true
          conn_type: false
        }
        {
          name: usbdev_bus_not_idle
          desc: Event signal that indicates that the USB was not idle while monitoring.
          struct: logic
          type: uni
          act: req
          width: 1
          default: 1'b0
          inst_name: pinmux
          package: ""
          domain: Aon
          top_signame: usbdev_usb_aon_bus_not_idle
          index: -1
          external: true
          conn_type: false
        }
        {
          name: usbdev_bus_reset
          desc: Event signal that indicates that the USB issued a Bus Reset while monitoring.
          struct: logic
          type: uni
          act: req
          width: 1
          default: 1'b0
          inst_name: pinmux
          package: ""
          domain: Aon
          top_signame: usbdev_usb_aon_bus_reset
          index: -1
          external: true
          conn_type: false
        }
        {
          name: usbdev_sense_lost
          desc: Event signal that indicates that USB SENSE signal was lost while monitoring.
          struct: logic
          type: uni
          act: req
          width: 1
          default: 1'b0
          inst_name: pinmux
          package: ""
          domain: Aon
          top_signame: usbdev_usb_aon_sense_lost
          index: -1
          external: true
          conn_type: false
        }
        {
          name: usbdev_wake_detect_active
          desc: State debug information.
          struct: logic
          type: uni
          act: req
          width: 1
          default: 1'b0
          inst_name: pinmux
          package: ""
          end_idx: -1
          top_type: broadcast
          top_signame: pinmux_usbdev_wake_detect_active
          index: -1
          external: true
          conn_type: false
        }
        {
          name: tl
          struct: tl
          package: tlul_pkg
          type: req_rsp
          act: rsp
          width: 1
          inst_name: pinmux
          default: ""
          end_idx: -1
          top_type: one-to-one
          top_signame: pinmux_tl
          index: -1
          external: true
          conn_type: false
        }
      ]
      base_addrs:
      {
        null:
        {
          hart: 0x40460000
        }
      }
      generate_dif: true
    }
    {
      name: aon_timer
      type: aon_timer
      clock_srcs:
      {
        clk_i: io_div4
        clk_aon_i: aon
      }
      clock_group: timers
      reset_connections:
      {
        rst_ni:
        {
          name: lc_io_div4
          domain: Aon
        }
        rst_aon_ni:
        {
          name: lc_aon
          domain: Aon
        }
      }
      domain: Aon
      clock_connections:
      {
        clk_i: clkmgr_clocks.clk_io_div4_timers
        clk_aon_i: clkmgr_clocks.clk_aon_timers
      }
      param_decl: {}
      memory: {}
      param_list: []
      inter_signal_list:
      [
        {
          name: nmi_wdog_timer_bark
          struct: logic
          type: uni
          act: req
          width: 1
          default: 1'b0
          inst_name: aon_timer
          package: ""
          end_idx: -1
          top_type: broadcast
          top_signame: aon_timer_nmi_wdog_timer_bark
          index: -1
          external: true
          conn_type: false
        }
        {
          name: wkup_req
          struct: logic
          type: uni
          act: req
          width: 1
          default: 1'b0
          inst_name: aon_timer
          package: ""
          domain: Aon
          top_signame: pwrmgr_wakeups
          index: 6
        }
        {
          name: aon_timer_rst_req
          struct: logic
          type: uni
          act: req
          width: 1
          default: 1'b0
          inst_name: aon_timer
          package: ""
          domain: Aon
          top_signame: pwrmgr_rstreqs
          index: 1
        }
        {
          name: lc_escalate_en
          struct: lc_tx
          package: lc_ctrl_pkg
          type: uni
          act: rcv
          width: 1
          default: lc_ctrl_pkg::Off
          inst_name: aon_timer
          domain: Aon
          top_signame: lc_ctrl_lc_escalate_en
          index: -1
          external: true
          conn_type: false
        }
        {
          name: sleep_mode
          struct: logic
          type: uni
          act: rcv
          width: 1
          inst_name: aon_timer
          default: ""
          package: ""
          domain: Aon
          top_signame: pwrmgr_low_power
          index: -1
        }
        {
          name: racl_policies
          desc:
            '''
            Incoming RACL policy vector from a racl_ctrl instance.
            The policy selection vector (parameter) selects the policy for each register.
            '''
          struct: racl_policy_vec
          package: top_racl_pkg
          type: uni
          act: rcv
          width: 1
          inst_name: aon_timer
          index: -1
        }
        {
          name: racl_error
          desc: RACL error log information of this module.
          struct: racl_error_log
          package: top_racl_pkg
          type: uni
          act: req
          width: 1
          inst_name: aon_timer
          index: -1
        }
        {
          name: tl
          struct: tl
          package: tlul_pkg
          type: req_rsp
          act: rsp
          width: 1
          inst_name: aon_timer
          default: ""
          end_idx: -1
          top_type: one-to-one
          top_signame: aon_timer_tl
          index: -1
          external: true
          conn_type: false
        }
      ]
      base_addrs:
      {
        null:
        {
          hart: 0x40470000
        }
      }
      generate_dif: true
    }
    {
      name: ast
      type: ast
      clock_srcs:
      {
        clk_ast_tlul_i:
        {
          clock: io_div4
          group: infra
        }
        clk_ast_es_i:
        {
          clock: main
          group: secure
        }
        clk_ast_rng_i:
        {
          clock: main
          group: secure
        }
        clk_ast_usb_i:
        {
          clock: usb
          group: peri
        }
        clk_ast_ext_i: ast_ext
      }
      clock_group: secure
      reset_connections:
      {
        rst_ast_tlul_ni:
        {
          name: lc_io_div4
          domain: Main
        }
        rst_ast_es_ni:
        {
          name: lc
          domain: Main
        }
        rst_ast_rng_ni:
        {
          name: lc
          domain: Main
        }
        rst_ast_usb_ni:
        {
          name: usb
          domain: Main
        }
      }
      domain: Main
      domain_secondary: Aon
      attr: reggen_top
      clock_srcs_secondary:
      {
        clk_ast_adc_i:
        {
          clock: aon
          group: peri
        }
        clk_ast_alert_i:
        {
          clock: io_div4
          group: secure
        }
        clk_ast_ext_i: ast_ext
      }
      clock_group_secondary: secure
      reset_connections_secondary:
      {
        rst_ast_adc_ni:
        {
          name: lc_aon
          domain: Aon
        }
        rst_ast_alert_ni:
        {
          name: lc_io_div4
          domain: Main
        }
      }
      clock_connections:
      {
        clk_ast_tlul_i: clkmgr_clocks_i.clk_io_div4_infra
        clk_ast_es_i: clkmgr_clocks_i.clk_main_secure
        clk_ast_rng_i: clkmgr_clocks_i.clk_main_secure
        clk_ast_usb_i: clkmgr_clocks_i.clk_usb_peri
        clk_ast_ext_i: clk_ast_ext_i
      }
      clock_connections_secondary:
      {
        clk_ast_adc_i: clkmgr_clocks.clk_aon_peri
        clk_ast_alert_i: clkmgr_clocks.clk_io_div4_secure
        clk_ast_ext_i: clk_ast_ext_i
      }
      param_decl: {}
      is_split_ip: true
      memory: {}
      param_list:
      [
        {
          name: EntropyStreams
          desc: Number of RNG bit streams
          type: int unsigned
          default: 4
          local: "true"
          expose: "true"
          name_top: AstEntropyStreams
        }
        {
          name: UsbCalibWidth
          desc: Width of the USB IO pull-up calibration setting
          type: int unsigned
          partition: secondary
          default: 20
          local: "false"
          expose: "true"
          name_top: AstUsbCalibWidth
        }
        {
          name: Pad2AstInWidth
          desc: Width of the DFT pad-to-AST input signal bus
          type: int unsigned
          partition: secondary
          default: 8
          local: "false"
          expose: "true"
          name_top: AstPad2AstInWidth
        }
        {
          name: Ast2PadOutWidth
          desc: Width of the DFT AST-to-pad output signal bus
          type: int unsigned
          partition: secondary
          default: 9
          local: "true"
          expose: "true"
          name_top: AstAst2PadOutWidth
        }
      ]
      inter_signal_list:
      [
        {
          name: rng_b
          desc: RNG bit stream(s) generated
          struct: logic
          type: uni
          act: req
          width:
          {
            name: EntropyStreams
            desc: Number of RNG bit streams
            param_type: int unsigned
            unpacked_dimensions: null
            default: 4
            local: true
            expose: true
            name_top: AstEntropyStreams
          }
          inst_name: ast
          default: ""
          package: ""
          end_idx: -1
          top_type: broadcast
          top_signame: ast_rng_b
          index: -1
        }
        {
          name: init_done
          desc: AST (registers) init done
          struct: mubi4
          package: prim_mubi_pkg
          type: uni
          act: req
          width: 1
          inst_name: ast
          default: ""
          end_idx: -1
          top_type: broadcast
          top_signame: ast_init_done
          index: -1
          external: true
          conn_type: false
        }
        {
          name: rng_en
          desc: RNG enable
          struct: logic
          type: uni
          act: rcv
          width: 1
          inst_name: ast
          default: ""
          package: ""
          domain: Main
          top_signame: entropy_src_entropy_src_rng_enable
          index: -1
        }
        {
          name: rng_fips
          desc: RNG FIPS
          struct: logic
          type: uni
          act: rcv
          width: 1
          inst_name: ast
          default: ""
          package: ""
          domain: Main
          top_signame: entropy_src_rng_fips
          index: -1
        }
        {
          name: rng_val
          desc: RNG valid
          struct: logic
          type: uni
          act: req
          width: 1
          inst_name: ast
          default: ""
          package: ""
          end_idx: -1
          top_type: broadcast
          top_signame: ast_rng_val
          index: -1
        }
        {
          name: edn
          desc: Entropy distribution request/response
          struct: edn
          package: edn_pkg
          type: req_rsp
          act: req
          width: 1
          inst_name: ast
          default: ""
          domain: Main
          top_signame: edn0_edn
          index: 2
        }
        {
          name: clk_src_sys_jen
          desc: SYS source clock jitter enable
          struct: mubi4
          package: prim_mubi_pkg
          type: uni
          act: rcv
          width: 1
          inst_name: ast
          default: ""
          end_idx: -1
          top_type: broadcast
          top_signame: ast_clk_src_sys_jen
          index: -1
          external: true
          conn_type: false
        }
        {
          name: clk_src_sys
          desc: SYS source clock
          struct: logic
          type: uni
          act: req
          width: 1
          inst_name: ast
          index: -1
          package: ""
          default: ""
          top_signame: ast_clk_src_sys
          conn_type: false
          external: true
        }
        {
          name: clk_src_io
          desc: IO source clock
          struct: logic
          type: uni
          act: req
          width: 1
          inst_name: ast
          index: -1
          package: ""
          default: ""
          top_signame: ast_clk_src_io
          conn_type: false
          external: true
        }
        {
          name: clk_src_io_48m
          desc: IO source clock is 48MHz
          struct: mubi4
          package: prim_mubi_pkg
          type: uni
          act: req
          width: 1
          inst_name: ast
          default: ""
          domain: Main
          top_signame: clkmgr_div_step_down_req
          index: -1
          external: true
          conn_type: false
        }
        {
          name: clk_src_usb
          desc: USB source clock
          struct: logic
          type: uni
          act: req
          width: 1
          inst_name: ast
          index: -1
          package: ""
          default: ""
          top_signame: ast_clk_src_usb
          conn_type: false
          external: true
        }
        {
          name: io_clk_byp_ack
          desc: Switch IO clock to external clock ack
          struct: mubi4
          package: prim_mubi_pkg
          type: uni
          act: req
          width: 1
          inst_name: ast
          default: ""
          domain: Main
          top_signame: clkmgr_io_clk_byp_ack
          index: -1
          external: true
          conn_type: false
        }
        {
          name: all_clk_byp_ack
          desc: Switch all clocks to external clocks ack
          struct: mubi4
          package: prim_mubi_pkg
          type: uni
          act: req
          width: 1
          inst_name: ast
          default: ""
          domain: Main
          top_signame: clkmgr_all_clk_byp_ack
          index: -1
          external: true
          conn_type: false
        }
        {
          name: usb_io_pu_cal
          desc: USB IO pull-up calibration setting
          struct: logic
          type: uni
          act: req
          width:
          {
            name: UsbCalibWidth
            desc: Width of the USB IO pull-up calibration setting
            param_type: int unsigned
            unpacked_dimensions: null
            partition: secondary
            default: 20
            local: false
            expose: true
            name_top: AstUsbCalibWidth
          }
          partition: secondary
          inst_name: ast
          default: ""
          package: ""
          external: true
          conn_type: false
          index: -1
          top_signame: usb_io_pu_cal
        }
        {
          name: adc
          desc: ADC interface
          struct: adc_ast
          package: ast_pkg
          type: req_rsp
          act: rsp
          width: 1
          partition: secondary
          inst_name: ast
          default: ""
          end_idx: -1
          top_type: one-to-one
          top_signame: ast_adc
          index: -1
        }
        {
          name: adc_a0_a
          desc: ADC A0 Analog Input
          struct: awire
          package: ast_pkg
          type: uni
          act: rcv
          width: 1
          partition: secondary
          inst_name: ast
          default: ""
          external: true
          conn_type: false
          index: -1
          top_signame: ast_adc_a0_a
        }
        {
          name: adc_a1_a
          desc: ADC A1 Analog Input
          struct: awire
          package: ast_pkg
          type: uni
          act: rcv
          width: 1
          partition: secondary
          inst_name: ast
          default: ""
          external: true
          conn_type: false
          index: -1
          top_signame: ast_adc_a1_a
        }
        {
          name: ast2pad_t0_a
          desc: AST_2_PAD Analog T0 Output Signal
          struct: awire
          package: ast_pkg
          type: uni
          act: req
          width: 1
          partition: secondary
          inst_name: ast
          default: ""
          external: true
          conn_type: false
          index: -1
          top_signame: ast2pad_t0_a
        }
        {
          name: ast2pad_t1_a
          desc: AST_2_PAD Analog T1 Output Signal
          struct: awire
          package: ast_pkg
          type: uni
          act: req
          width: 1
          partition: secondary
          inst_name: ast
          default: ""
          external: true
          conn_type: false
          index: -1
          top_signame: ast2pad_t1_a
        }
        {
          name: padmux2ast
          desc: IO-to-DFT input signals
          struct: logic
          type: uni
          act: rcv
          width:
          {
            name: Pad2AstInWidth
            desc: Width of the DFT pad-to-AST input signal bus
            param_type: int unsigned
            unpacked_dimensions: null
            partition: secondary
            default: 8
            local: false
            expose: true
            name_top: AstPad2AstInWidth
          }
          partition: secondary
          inst_name: ast
          default: ""
          package: ""
          external: true
          conn_type: false
          index: -1
          top_signame: padmux2ast
        }
        {
          name: ast2padmux
          desc: DFT-to-IO output signals
          struct: logic
          type: uni
          act: req
          width:
          {
            name: Ast2PadOutWidth
            desc: Width of the DFT AST-to-pad output signal bus
            param_type: int unsigned
            unpacked_dimensions: null
            partition: secondary
            default: 9
            local: true
            expose: true
            name_top: AstAst2PadOutWidth
          }
          partition: secondary
          inst_name: ast
          default: ""
          package: ""
          end_idx: -1
          top_type: broadcast
          top_signame: ast_ast2padmux
          index: -1
        }
        {
          name: por_n
          desc: External power ON reset based on VCC
          struct: logic
          type: uni
          act: rcv
          width: 1
          partition: secondary
          inst_name: ast
          default: ""
          package: ""
          external: true
          conn_type: false
          index: -1
          top_signame: manual_in_por_n
        }
        {
          name: pora_n
          desc: External power ON reset based on VIOA
          struct: logic
          type: uni
          act: rcv
          width: 1
          partition: secondary
          inst_name: ast
          default: ""
          package: ""
          external: true
          conn_type: false
          index: -1
          top_signame: manual_in_pora_n
        }
        {
          name: sns_clks
          desc: Sensed clocks
          struct: clkmgr_out
          package: clkmgr_pkg
          type: uni
          act: rcv
          width: 1
          partition: secondary
          inst_name: ast
          default: ""
          end_idx: -1
          top_type: broadcast
          top_signame: ast_sns_clks
          index: -1
        }
        {
          name: sns_rsts
          desc: Sensed resets
          struct: rstmgr_out
          package: rstmgr_pkg
          type: uni
          act: rcv
          width: 1
          partition: secondary
          inst_name: ast
          default: ""
          end_idx: -1
          top_type: broadcast
          top_signame: ast_sns_rsts
          index: -1
        }
        {
          name: vx_supp
          desc: Supply voltage tests for OS FPGA
          struct: ast_vx_supp
          package: ast_pkg
          type: uni
          act: rcv
          width: 1
          partition: secondary
          inst_name: ast
          default: ""
          external: true
          conn_type: false
          index: -1
          top_signame: ast_vx_supp
        }
        {
          name: ast_pwst_h
          desc: AON, MAIN, IO-0 rail, IO-1 rail power OK @3.3V
          struct: ast_pwst
          package: ast_pkg
          type: uni
          act: req
          width: 1
          partition: secondary
          inst_name: ast
          default: ""
          external: true
          conn_type: false
          index: -1
          top_signame: ast_pwst_h
        }
        {
          name: rstmgr_por_n
          desc: Per-power-domain power-on-reset for rstmgr
          struct: logic
          type: uni
          act: req
          width: 2
          partition: secondary
          inst_name: ast
          default: ""
          package: ""
          domain: Aon
          top_signame: rstmgr_por_n
          index: -1
        }
        {
          name: io_pwr_st
          desc: IO power state
          struct: ast_status
          package: ast_pkg
          type: uni
          act: req
          width: 1
          partition: secondary
          inst_name: ast
          default: ""
          end_idx: -1
          top_type: broadcast
          top_signame: ast_io_pwr_st
          index: -1
        }
        {
          name: pwrmgr
          desc: Interface to pwrmgr
          struct: pwr_ast
          package: pwrmgr_pkg
          type: req_rsp
          act: rsp
          width: 1
          partition: secondary
          inst_name: ast
          default: ""
          domain: Aon
          top_signame: pwrmgr_pwr_ast
          index: -1
        }
        {
          name: flash_power_down_h
          desc: Flash power down
          struct: logic
          type: uni
          act: req
          width: 1
          partition: secondary
          inst_name: ast
          index: -1
        }
        {
          name: flash_power_ready_h
          desc: Flash power ready
          struct: logic
          type: uni
          act: req
          width: 1
          partition: secondary
          inst_name: ast
          index: -1
        }
        {
          name: otp_power_seq
          desc: OTP power sequencing, in (VDD)
          struct: logic
          type: uni
          act: rcv
          width: 2
          partition: secondary
          inst_name: ast
          index: -1
        }
        {
          name: otp_power_seq_h
          desc: OTP power sequencing masked by PDM, out (VCC)
          struct: logic
          type: uni
          act: req
          width: 2
          partition: secondary
          inst_name: ast
          index: -1
        }
        {
          name: clk_src_aon
          desc: AON source clock
          struct: logic
          type: uni
          act: req
          width: 1
          partition: secondary
          inst_name: ast
          default: ""
          package: ""
          top_signame: ast_clk_src_aon
          index: -1
        }
        {
          name: usb_ref_pulse
          desc: USB reference pulse
          struct: logic
          type: uni
          act: rcv
          width: 1
          inst_name: ast
          default: ""
          package: ""
          domain: Main
          top_signame: usbdev_usb_ref_pulse
          index: -1
        }
        {
          name: usb_ref_val
          desc: USB reference valid
          struct: logic
          type: uni
          act: rcv
          width: 1
          inst_name: ast
          default: ""
          package: ""
          domain: Main
          top_signame: usbdev_usb_ref_val
          index: -1
        }
        {
          name: alert
          desc: Analog alert events to sensor_ctrl
          struct: ast_alert
          package: ast_pkg
          type: req_rsp
          act: req
          width: 1
          partition: secondary
          inst_name: ast
          default: ""
          domain: Aon
          top_signame: sensor_ctrl_ast_alert
          index: -1
        }
        {
          name: dft_strap_test
          desc: DFT straps
          struct: dft_strap_test_req
          package: pinmux_pkg
          type: uni
          act: rcv
          width: 1
          partition: secondary
          inst_name: ast
          default: ""
          domain: Aon
          top_signame: pinmux_dft_strap_test
          index: -1
        }
        {
          name: lc_dft_en
          desc: DFT enable (secure bus)
          struct: lc_tx
          package: lc_ctrl_pkg
          type: uni
          act: rcv
          width: 1
          partition: secondary
          inst_name: ast
          default: ""
          domain: Aon
          top_signame: lc_ctrl_lc_dft_en
          index: -1
          external: true
          conn_type: false
        }
        {
          name: obs
          desc: Observe bus
          struct: ast_obs_bus
          package: ast_pkg
          type: uni
          act: rcv
          width: 1
          partition: secondary
          inst_name: ast
          default: ""
          external: true
          conn_type: false
          index: -1
          top_signame: ast_obs
        }
        {
          name: obs_ctrl
          desc: Observe control
          struct: ast_obs_ctrl
          package: ast_pkg
          type: uni
          act: req
          width: 1
          partition: secondary
          inst_name: ast
          default: ""
          end_idx: -1
          top_type: broadcast
          top_signame: ast_obs_ctrl
          index: -1
          external: true
          conn_type: false
        }
        {
          name: flash_bist_en
          desc: Flash BIST (TAP) enable
          struct: mubi4
          package: prim_mubi_pkg
          type: uni
          act: req
          width: 1
          partition: secondary
          inst_name: ast
          index: -1
        }
        {
          name: dft_scan_md
          desc: Scan mode output
          struct: mubi4
          package: prim_mubi_pkg
          type: uni
          act: req
          width: 1
          partition: secondary
          inst_name: ast
          default: ""
          external: true
          conn_type: false
          index: -1
          top_signame: scanmode
        }
        {
          name: scan_shift_en
          desc: Scan shift enable output
          struct: logic
          type: uni
          act: req
          width: 1
          partition: secondary
          inst_name: ast
          default: ""
          package: ""
          external: true
          conn_type: false
          index: -1
          top_signame: scan_en
        }
        {
          name: scan_reset_n
          desc: Scan reset output
          struct: logic
          type: uni
          act: req
          width: 1
          partition: secondary
          inst_name: ast
          default: ""
          package: ""
          external: true
          conn_type: false
          index: -1
          top_signame: scan_rst_n
        }
        {
          name: mem_cfg
          desc: Memory configuration
          struct: ast_mem_cfg_primary
          package: ast_pkg
          type: req_rsp
          act: req
          width: 1
          inst_name: ast
          default: ""
          top_signame: ast_mem_cfg
          index: -1
        }
        {
          name: mem_cfg
          desc: Memory configuration
          struct: ast_mem_cfg_secondary
          package: ast_pkg
          type: req_rsp
          act: req
          width: 1
          partition: secondary
          inst_name: ast
          default: ""
          top_signame: ast_mem_cfg
          index: -1
        }
        {
          name: clk_osc_byp
          desc: Clocks' oscillator bypass for OS FPGA/Verilator (AST_BYPASS_CLK only)
          struct: clks_osc_byp
          package: ast_pkg
          type: uni
          act: rcv
          width: 1
          inst_name: ast
          default: ""
          top_signame: ast_clk_osc_byp
          index: -1
          external: true
          conn_type: true
        }
        {
          name: ext_freq_is_96m
          desc: External clock frequency is 96MHz
          struct: mubi4
          package: prim_mubi_pkg
          type: uni
          act: rcv
          width: 1
          inst_name: ast
          default: ""
          domain: Main
          top_signame: clkmgr_hi_speed_sel
          index: -1
          external: true
          conn_type: false
        }
        {
          name: all_clk_byp_req
          desc: All clocks bypass request
          struct: mubi4
          package: prim_mubi_pkg
          type: uni
          act: rcv
          width: 1
          inst_name: ast
          default: ""
          domain: Main
          top_signame: clkmgr_all_clk_byp_req
          index: -1
          external: true
          conn_type: false
        }
        {
          name: io_clk_byp_req
          desc: IO clock bypass request (for OTP bootstrap)
          struct: mubi4
          package: prim_mubi_pkg
          type: uni
          act: rcv
          width: 1
          inst_name: ast
          default: ""
          domain: Main
          top_signame: clkmgr_io_clk_byp_req
          index: -1
          external: true
          conn_type: false
        }
        {
          name: intraip_s2p
          desc: Secondary-to-Primary partition communication
          struct: s2p
          package: ast_intraip_pkg
          type: uni
          act: rcv
          width: 1
          inst_name: ast
          default: ""
          domain: Main
          top_signame: ast_intraip_s2p
          index: -1
          external: true
          conn_type: false
        }
        {
          name: intraip_p2s
          desc: Primary-to-Secondary partition communication
          struct: p2s
          package: ast_intraip_pkg
          type: uni
          act: req
          width: 1
          inst_name: ast
          default: ""
          end_idx: -1
          top_type: broadcast
          top_signame: ast_intraip_p2s
          index: -1
          external: true
          conn_type: false
        }
        {
          name: intraip_s2p
          desc: Secondary-to-Primary partition communication
          struct: s2p
          package: ast_intraip_pkg
          type: uni
          act: req
          width: 1
          partition: secondary
          inst_name: ast
          default: ""
          end_idx: -1
          top_type: broadcast
          top_signame: ast_intraip_s2p
          index: -1
          external: true
          conn_type: false
        }
        {
          name: intraip_p2s
          desc: Primary-to-Secondary partition communication
          struct: p2s
          package: ast_intraip_pkg
          type: uni
          act: rcv
          width: 1
          partition: secondary
          inst_name: ast
          default: ""
          domain: Aon
          top_signame: ast_intraip_p2s
          index: -1
          external: true
          conn_type: false
        }
        {
          name: tl
          struct: tl
          package: tlul_pkg
          type: req_rsp
          act: rsp
          width: 1
          inst_name: ast
          default: ""
          end_idx: -1
          top_type: one-to-one
          top_signame: ast_tl
          index: -1
        }
      ]
      base_addrs:
      {
        null:
        {
          hart: 0x40480000
        }
      }
      generate_dif: true
    }
    {
      name: sensor_ctrl
      type: sensor_ctrl
      clock_srcs:
      {
        clk_i: io_div4
        clk_aon_i: aon
      }
      clock_group: secure
      reset_connections:
      {
        rst_ni:
        {
          name: lc_io_div4
          domain: Aon
        }
        rst_aon_ni:
        {
          name: lc_aon
          domain: Aon
        }
      }
      domain: Aon
      attr: reggen_top
      clock_connections:
      {
        clk_i: clkmgr_clocks.clk_io_div4_secure
        clk_aon_i: clkmgr_clocks.clk_aon_secure
      }
      param_decl: {}
      memory: {}
      param_list: []
      inter_signal_list:
      [
        {
          name: ast_alert
          struct: ast_alert
          package: ast_pkg
          type: req_rsp
          act: rsp
          width: 1
          inst_name: sensor_ctrl
          default: ""
          end_idx: -1
          top_type: one-to-one
          top_signame: sensor_ctrl_ast_alert
          index: -1
        }
        {
          name: ast_status
          struct: ast_status
          package: ast_pkg
          type: uni
          act: rcv
          width: 1
          inst_name: sensor_ctrl
          default: ""
          domain: Aon
          top_signame: ast_io_pwr_st
          index: -1
        }
        {
          name: ast_init_done
          struct: mubi4
          package: prim_mubi_pkg
          type: uni
          act: rcv
          width: 1
          default: prim_mubi_pkg::MuBi4True
          inst_name: sensor_ctrl
          domain: Aon
          top_signame: ast_init_done
          index: -1
          external: true
          conn_type: false
        }
        {
          name: ast2pinmux
          struct: logic
          type: uni
          act: rcv
          width: 9
          inst_name: sensor_ctrl
          default: ""
          package: ""
          domain: Aon
          top_signame: ast_ast2padmux
          index: -1
        }
        {
          name: wkup_req
          struct: logic
          type: uni
          act: req
          width: 1
          inst_name: sensor_ctrl
          default: ""
          package: ""
          domain: Aon
          top_signame: pwrmgr_wakeups
          index: 7
        }
        {
          name: manual_pad_attr
          struct: pad_attr
          package: prim_pad_wrapper_pkg
          type: uni
          act: req
          width: 4
          default: "'0"
          inst_name: sensor_ctrl
          external: true
          conn_type: false
          index: -1
          top_signame: sensor_ctrl_manual_pad_attr
        }
        {
          name: tl
          struct: tl
          package: tlul_pkg
          type: req_rsp
          act: rsp
          width: 1
          inst_name: sensor_ctrl
          default: ""
          end_idx: -1
          top_type: one-to-one
          top_signame: sensor_ctrl_tl
          index: -1
          external: true
          conn_type: false
        }
      ]
      base_addrs:
      {
        null:
        {
          hart: 0x40490000
        }
      }
      generate_dif: true
    }
    {
      name: sram_ctrl_ret
      type: sram_ctrl
      clock_srcs:
      {
        clk_i: io_div4
        clk_otp_i: io_div4
      }
      clock_group: infra
      reset_connections:
      {
        rst_ni:
        {
          name: lc_io_div4
          domain: Aon
        }
        rst_otp_ni:
        {
          name: lc_io_div4
          domain: Aon
        }
      }
      domain: Aon
      param_decl:
      {
        InstrExec: "0"
        InstSize: "8192"
      }
      base_addrs:
      {
        regs:
        {
          hart: 0x40500000
        }
        ram:
        {
          hart: 0x40600000
        }
      }
      memory:
      {
        ram:
        {
          label: ram_ret_aon
          swaccess: rw
          data_intg_passthru: "true"
          exec: True
          byte_write: True
          size: 0x2000
        }
      }
      clock_connections:
      {
        clk_i: clkmgr_clocks.clk_io_div4_infra
        clk_otp_i: clkmgr_clocks.clk_io_div4_infra
      }
      param_list:
      [
        {
          name: MemSizeRam
          desc:
            '''
            Memory size of the RAM (in bytes).
            If address scrambling is enabled, this must be a power of 2 or a multiple of 16 KiB.
            For details, check the SRAM scrambling primitive (prim_ram_1p_scr).
            '''
          type: int
          name_top: MemSizeSramCtrlRetRam
          default: 8192
        }
        {
          name: InstSize
          desc: Memory size of a single RAM tile (in bytes).
          type: int
          default: "8192"
          local: "false"
          expose: "true"
          name_top: SramCtrlRetInstSize
        }
        {
          name: NumRamInst
          desc: Number of internal RAM instances. Must be the same as ceil(MemSizeRam / InstSize) .
          type: int
          default: 1
          local: "false"
          expose: "true"
          name_top: SramCtrlRetNumRamInst
        }
        {
          name: InstrExec
          desc: Support execution from SRAM
          type: bit
          default: "0"
          local: "false"
          expose: "true"
          name_top: SramCtrlRetInstrExec
        }
        {
          name: NumPrinceRoundsHalf
          desc: Number of PRINCE half rounds for the SRAM scrambling feature
          type: int
          default: "3"
          local: "false"
          expose: "true"
          name_top: SramCtrlRetNumPrinceRoundsHalf
        }
        {
          name: NumAddrScrRounds
          desc: Number of address scrambling rounds. 0 disables address scrambling.
          type: int
          default: "2"
          local: "false"
          expose: "true"
          name_top: SramCtrlRetNumAddrScrRounds
        }
        {
          name: Outstanding
          desc: Number of outstanding TLUL transactions
          type: int
          default: "2"
          local: "true"
          expose: "true"
          name_top: SramCtrlRetOutstanding
        }
        {
          name: EccCorrection
          desc: Enable single-bit error correction and error logging
          type: bit
          default: "0"
          local: "false"
          expose: "true"
          name_top: SramCtrlRetEccCorrection
        }
        {
          name: SecZeroInit
          desc: Initialize the memory with zeros instead of pseudo-random data.
          type: bit
          default: "0"
          local: "false"
          expose: "true"
          name_top: SecSramCtrlRetZeroInit
        }
      ]
      inter_signal_list:
      [
        {
          name: sram_otp_key
          struct: sram_otp_key
          package: otp_ctrl_pkg
          type: req_rsp
          act: req
          width: 1
          inst_name: sram_ctrl_ret
          default: ""
          domain: Aon
          top_signame: otp_ctrl_sram_otp_key
          index: -1
          external: true
          conn_type: false
        }
        {
          name: ram_cfg
          struct: ram_1p_cfg
          package: prim_ram_1p_pkg
          type: req_rsp
          act: rsp
          width:
          {
            name: NumRamInst
            desc: Number of internal RAM instances. Must be the same as ceil(MemSizeRam / InstSize) .
            param_type: int
            unpacked_dimensions: null
            default: 1
            local: false
            expose: true
            name_top: SramCtrlRetNumRamInst
          }
          inst_name: sram_ctrl_ret
          default: ""
          top_signame: sram_ctrl_ret_ram_cfg
          index: -1
        }
        {
          name: lc_escalate_en
          struct: lc_tx
          package: lc_ctrl_pkg
          type: uni
          act: rcv
          width: 1
          default: lc_ctrl_pkg::Off
          inst_name: sram_ctrl_ret
          domain: Aon
          top_signame: lc_ctrl_lc_escalate_en
          index: -1
          external: true
          conn_type: false
        }
        {
          name: lc_hw_debug_en
          struct: lc_tx
          package: lc_ctrl_pkg
          type: uni
          act: rcv
          width: 1
          default: lc_ctrl_pkg::Off
          inst_name: sram_ctrl_ret
          index: -1
        }
        {
          name: otp_en_sram_ifetch
          struct: mubi8
          package: prim_mubi_pkg
          type: uni
          act: rcv
          width: 1
          default: prim_mubi_pkg::MuBi8False
          inst_name: sram_ctrl_ret
          index: -1
        }
        {
          name: racl_policies
          desc:
            '''
            Incoming RACL policy vector from a racl_ctrl instance.
            The policy selection vector (parameter) selects the policy for each register.
            '''
          struct: racl_policy_vec
          package: top_racl_pkg
          type: uni
          act: rcv
          width: 1
          inst_name: sram_ctrl_ret
          index: -1
        }
        {
          name: racl_error
          desc: RACL error log information of this module.
          struct: racl_error_log
          package: top_racl_pkg
          type: uni
          act: req
          width: 1
          inst_name: sram_ctrl_ret
          index: -1
        }
        {
          name: sram_rerror
          desc: SRAM read error indicating correctable and uncorrectable ECC errors.
          struct: sram_error_t
          package: sram_ctrl_pkg
          type: uni
          act: req
          width: 1
          inst_name: sram_ctrl_ret
          index: -1
        }
        {
          name: regs_tl
          struct: tl
          package: tlul_pkg
          type: req_rsp
          act: rsp
          width: 1
          inst_name: sram_ctrl_ret
          default: ""
          end_idx: -1
          top_type: one-to-one
          top_signame: sram_ctrl_ret_regs_tl
          index: -1
          external: true
          conn_type: false
        }
        {
          name: ram_tl
          struct: tl
          package: tlul_pkg
          type: req_rsp
          act: rsp
          width: 1
          inst_name: sram_ctrl_ret
          default: ""
          end_idx: -1
          top_type: one-to-one
          top_signame: sram_ctrl_ret_ram_tl
          index: -1
          external: true
          conn_type: false
        }
      ]
      generate_dif: true
    }
    {
      name: rram_ctrl
      type: rram_ctrl
      clock_srcs:
      {
        clk_i: main
        clk_otp_i: io_div4
      }
      clock_group: infra
      reset_connections:
      {
        rst_ni:
        {
          name: lc
          domain: Main
        }
        rst_otp_ni:
        {
          name: lc_io_div4
          domain: Main
        }
      }
      base_addrs:
      {
        core:
        {
          hart: 0x41010000
        }
        host:
        {
          hart: 0x30000000
        }
      }
      param_decl:
      {
        WrFifoDepth: "4"
        RdFifoDepth: "16"
      }
      memory:
      {
        host:
        {
          label: rram
          swaccess: ro
          data_intg_passthru: "true"
          exec: True
          byte_write: False
          size: 0x200000
        }
      }
      domain: Main
      clock_connections:
      {
        clk_i: clkmgr_clocks_i.clk_main_infra
        clk_otp_i: clkmgr_clocks_i.clk_io_div4_infra
      }
      param_list:
      [
        {
          name: SecScrambleEn
          desc: Compile-time option to enable RRAM scrambling
          type: bit
          default: "1"
          local: "false"
          expose: "true"
          name_top: SecRramCtrlScrambleEn
        }
        {
          name: WrFifoDepth
          desc: Depth of write fifo
          type: int
          default: "4"
          local: "false"
          expose: "true"
          name_top: RramCtrlWrFifoDepth
        }
        {
          name: RdFifoDepth
          desc: Depth of read fifo
          type: int
          default: "16"
          local: "false"
          expose: "true"
          name_top: RramCtrlRdFifoDepth
        }
      ]
      inter_signal_list:
      [
        {
          name: rram_macro
          struct: rram_macro
          package: rram_ctrl_pkg
          type: req_rsp
          act: req
          width: 1
          inst_name: rram_ctrl
          default: ""
          end_idx: -1
          top_type: one-to-one
          top_signame: rram_ctrl_rram_macro
          index: -1
        }
        {
          name: otp_key
          struct: nvm_otp_key
          package: otp_ctrl_pkg
          type: req_rsp
          act: req
          width: 1
          inst_name: rram_ctrl
          default: ""
          end_idx: -1
          top_type: one-to-one
          top_signame: rram_ctrl_otp_key
          index: -1
        }
        {
          name: otp_macro
          desc: Data interface for the OTP macro.
          struct: otp_ctrl_macro
          package: otp_ctrl_macro_pkg
          type: req_rsp
          act: rsp
          width: 1
          default: "'0"
          inst_name: rram_ctrl
          domain: Main
          top_signame: otp_ctrl_otp_macro
          index: -1
        }
        {
          name: lc_creator_seed_sw_rw_en
          struct: lc_tx
          package: lc_ctrl_pkg
          type: uni
          act: rcv
          width: 1
          inst_name: rram_ctrl
          default: ""
          domain: Main
          top_signame: lc_ctrl_lc_creator_seed_sw_rw_en
          index: -1
        }
        {
          name: lc_owner_seed_sw_rw_en
          struct: lc_tx
          package: lc_ctrl_pkg
          type: uni
          act: rcv
          width: 1
          inst_name: rram_ctrl
          default: ""
          domain: Main
          top_signame: lc_ctrl_lc_owner_seed_sw_rw_en
          index: -1
        }
        {
          name: lc_iso_part_sw_rd_en
          struct: lc_tx
          package: lc_ctrl_pkg
          type: uni
          act: rcv
          width: 1
          inst_name: rram_ctrl
          default: ""
          domain: Main
          top_signame: lc_ctrl_lc_iso_part_sw_rd_en
          index: -1
        }
        {
          name: lc_iso_part_sw_wr_en
          struct: lc_tx
          package: lc_ctrl_pkg
          type: uni
          act: rcv
          width: 1
          inst_name: rram_ctrl
          default: ""
          domain: Main
          top_signame: lc_ctrl_lc_iso_part_sw_wr_en
          index: -1
        }
        {
          name: lc_seed_hw_rd_en
          struct: lc_tx
          package: lc_ctrl_pkg
          type: uni
          act: rcv
          width: 1
          inst_name: rram_ctrl
          default: ""
          domain: Main
          top_signame: lc_ctrl_lc_seed_hw_rd_en
          index: -1
        }
        {
          name: lc_escalate_en
          struct: lc_tx
          package: lc_ctrl_pkg
          type: uni
          act: rcv
          width: 1
          inst_name: rram_ctrl
          default: ""
          domain: Main
          top_signame: lc_ctrl_lc_escalate_en
          index: -1
        }
        {
          name: rma_req
          struct: lc_tx
          package: lc_ctrl_pkg
          type: uni
          act: rcv
          width: 1
          inst_name: rram_ctrl
          default: ""
          domain: Main
          top_signame: lc_ctrl_lc_nvm_rma_req
          index: -1
        }
        {
          name: rma_ack
          struct: lc_tx
          package: lc_ctrl_pkg
          type: uni
          act: req
          width: 1
          inst_name: rram_ctrl
          default: ""
          domain: Main
          top_signame: lc_ctrl_lc_nvm_rma_ack
          index: 0
        }
        {
          name: rma_seed
          struct: lc_nvm_rma_seed
          package: lc_ctrl_pkg
          type: uni
          act: rcv
          width: 1
          inst_name: rram_ctrl
          default: ""
          domain: Main
          top_signame: lc_ctrl_lc_nvm_rma_seed
          index: -1
        }
        {
          name: pwrmgr
          struct: pwr_nvm
          package: pwrmgr_pkg
          type: uni
          act: req
          width: 1
          inst_name: rram_ctrl
          default: ""
          domain: Main
          top_signame: pwrmgr_pwr_nvm
          index: -1
          external: true
          conn_type: false
        }
        {
          name: keymgr_creator_seed
          desc: Creator seed output to the key manager
          struct: keymgr_dpe_creator_seed
          package: keymgr_dpe_pkg
          type: uni
          act: req
          width: 1
          default: "'0"
          inst_name: rram_ctrl
          end_idx: -1
          top_type: broadcast
          top_signame: rram_ctrl_keymgr_creator_seed
          index: -1
        }
        {
          name: keymgr_owner_seed
          desc: Owner seed output to the key manager
          struct: keymgr_dpe_owner_seed
          package: keymgr_dpe_pkg
          type: uni
          act: req
          width: 1
          default: "'0"
          inst_name: rram_ctrl
          end_idx: -1
          top_type: broadcast
          top_signame: rram_ctrl_keymgr_owner_seed
          index: -1
        }
        {
          name: core_tl
          struct: tl
          package: tlul_pkg
          type: req_rsp
          act: rsp
          width: 1
          inst_name: rram_ctrl
          default: ""
          end_idx: -1
          top_type: one-to-one
          top_signame: rram_ctrl_core_tl
          index: -1
        }
        {
          name: host_tl
          struct: tl
          package: tlul_pkg
          type: req_rsp
          act: rsp
          width: 1
          inst_name: rram_ctrl
          default: ""
          end_idx: -1
          top_type: one-to-one
          top_signame: rram_ctrl_host_tl
          index: -1
        }
      ]
      generate_dif: true
    }
    {
      name: rram_macro
      type: rram_macro
      clock_srcs:
      {
        clk_i: main
      }
      clock_group: infra
      reset_connections:
      {
        rst_ni:
        {
          name: lc
          domain: Main
        }
      }
      base_addrs:
      {
        prim:
        {
          hart: 0x41018000
        }
      }
      param_decl:
      {
        TotalDataPages: rram_ctrl_pkg::TotalDataPages
        DataWidth: rram_ctrl_pkg::DataWidth
        WordsPerPage: rram_ctrl_pkg::WordsPerPage
        TotalInfoPages: rram_ctrl_pkg::TotalInfoPages
        MaxWrWords: rram_ctrl_pkg::MaxWrWords
      }
      domain: Main
      clock_connections:
      {
        clk_i: clkmgr_clocks_i.clk_main_infra
      }
      memory: {}
      param_list:
      [
        {
          name: TotalDataPages
          desc: Total number of data pages
          type: int
          default: rram_ctrl_pkg::TotalDataPages
          local: "true"
          expose: "true"
          name_top: RramMacroTotalDataPages
        }
        {
          name: DataWidth
          desc: RRAM word data width
          type: int
          default: rram_ctrl_pkg::DataWidth
          local: "true"
          expose: "true"
          name_top: RramMacroDataWidth
        }
        {
          name: WordsPerPage
          desc: Number of words per page
          type: int
          default: rram_ctrl_pkg::WordsPerPage
          local: "true"
          expose: "true"
          name_top: RramMacroWordsPerPage
        }
        {
          name: TotalInfoPages
          desc: Total number of info pages
          type: int
          default: rram_ctrl_pkg::TotalInfoPages
          local: "true"
          expose: "true"
          name_top: RramMacroTotalInfoPages
        }
        {
          name: MaxWrWords
          desc: Maximum number of words per write
          type: int
          default: rram_ctrl_pkg::MaxWrWords
          local: "true"
          expose: "true"
          name_top: RramMacroMaxWrWords
        }
      ]
      inter_signal_list:
      [
        {
          name: rram_macro
          struct: rram_macro
          package: rram_ctrl_pkg
          type: req_rsp
          act: rsp
          width: 1
          inst_name: rram_macro
          default: ""
          domain: Main
          top_signame: rram_ctrl_rram_macro
          index: -1
        }
        {
          name: lc_nvm_debug_en
          struct: lc_tx
          package: lc_ctrl_pkg
          type: uni
          act: rcv
          width: 1
          inst_name: rram_macro
          default: ""
          domain: Main
          top_signame: lc_ctrl_lc_nvm_debug_en
          index: -1
        }
        {
          name: jtag
          desc: JTAG signals for the RRAM TAP.
          struct: jtag
          package: jtag_pkg
          type: req_rsp
          act: rsp
          width: 1
          inst_name: rram_macro
          default: ""
          domain: Main
          top_signame: pinmux_rram_jtag
          index: -1
          external: true
          conn_type: false
        }
        {
          name: obs_ctrl
          desc: AST observability control signals.
          struct: ast_obs_ctrl
          package: ast_pkg
          type: uni
          act: rcv
          width: 1
          inst_name: rram_macro
          default: ""
          domain: Main
          top_signame: ast_obs_ctrl
          index: -1
          external: true
          conn_type: false
        }
        {
          name: rram_obs
          desc: AST observability bus.
          struct: logic
          type: uni
          act: req
          width: 8
          inst_name: rram_macro
          index: -1
        }
        {
          name: rram_test_analog
          struct: ""
          type: io
          act: none
          width: 1
          default: "'0"
          inst_name: rram_macro
          package: ""
          external: true
          conn_type: false
          index: -1
          top_signame: rram_test_analog
        }
        {
          name: prim_tl
          struct: tl
          package: tlul_pkg
          type: req_rsp
          act: rsp
          width: 1
          inst_name: rram_macro
          default: ""
          end_idx: -1
          top_type: one-to-one
          top_signame: rram_macro_prim_tl
          index: -1
        }
      ]
      generate_dif: true
    }
    {
      name: rv_dm
      type: rv_dm
      clock_srcs:
      {
        clk_i: main
        clk_lc_i: main
      }
      clock_group: infra
      reset_connections:
      {
        rst_ni:
        {
          name: sys
          domain: Main
        }
        rst_lc_ni:
        {
          name: lc
          domain: Main
        }
      }
      param_decl:
      {
        IdcodeValue: jtag_id_pkg::RV_DM_JTAG_IDCODE
        CheriotSupport: "1"
      }
      base_addrs:
      {
        mem:
        {
          hart: 0x00010000
        }
        regs:
        {
          hart: 0x41200000
        }
      }
      generate_dif: false
      domain: Main
      clock_connections:
      {
        clk_i: clkmgr_clocks_i.clk_main_infra
        clk_lc_i: clkmgr_clocks_i.clk_main_infra
      }
      memory: {}
      param_list:
      [
        {
          name: IdcodeValue
          desc: RISC-V debug module JTAG ID code.
          type: logic [31:0]
          default: jtag_id_pkg::RV_DM_JTAG_IDCODE
          local: "false"
          expose: "true"
          name_top: RvDmIdcodeValue
        }
        {
          name: UseDmiInterface
          desc: When 1, a TLUL-based DMI interface is used. When 0, a JTAG TAP is used.
          type: bit
          default: "0"
          local: "false"
          expose: "true"
          name_top: RvDmUseDmiInterface
        }
        {
          name: CheriotSupport
          desc: When 1, cheriot_ena can select CHERIoT mode. When 0, the CHERIoT logic is removed.
          type: bit
          default: "1"
          local: "false"
          expose: "true"
          name_top: RvDmCheriotSupport
        }
        {
          name: SecVolatileRawUnlockEn
          desc:
            '''
            Disable (0) or enable (1) volatile RAW UNLOCK capability.
            If enabled, the strap_en_override_i input can be used to re-sample the straps at runtime.
            IMPORTANT NOTE: This should only be used in test chips. The parameter must be set
            to 0 in production tapeouts since this weakens the security posture of the RAW
            UNLOCK mechanism.
            '''
          type: bit
          default: 1'b0
          local: "false"
          expose: "true"
          name_top: SecRvDmVolatileRawUnlockEn
        }
        {
          name: TlulHostUserRsvdBits
          desc: TLUL user bits sent on outgoing transfers.
          type: logic [tlul_pkg::RsvdWidth-1:0]
          default: "'0"
          local: "false"
          expose: "true"
          name_top: RvDmTlulHostUserRsvdBits
        }
      ]
      inter_signal_list:
      [
        {
          name: next_dm_addr
          desc:
            '''
            32bit word address of the next debug module.
            Set to 0x0 if this is the last debug module in the chain.
            '''
          struct: next_dm_addr
          package: rv_dm_pkg
          type: uni
          act: rcv
          width: 1
          default: "'0"
          inst_name: rv_dm
          index: -1
        }
        {
          name: jtag
          desc: JTAG signals for the RISC-V TAP.
          struct: jtag
          package: jtag_pkg
          type: req_rsp
          act: rsp
          width: 1
          inst_name: rv_dm
          default: ""
          domain: Main
          top_signame: pinmux_rv_jtag
          index: -1
          external: true
          conn_type: false
        }
        {
          name: cheriot_ena
          desc:
            '''
            CHERIoT mode enable.
            Selects which ROM and which abstract command encodings the debug module uses.
            Ignored unless CheriotSupport is set.
            '''
          struct: mubi4
          package: prim_mubi_pkg
          type: uni
          act: rcv
          width: 1
          default: prim_mubi_pkg::MuBi4False
          inst_name: rv_dm
          domain: Main
          top_signame: rv_core_ibex_cheriot_ena
          index: -1
        }
        {
          name: lc_init_done
          desc: Lifecycle initialization done signal coming from life cycle controller.
          struct: lc_tx
          package: lc_ctrl_pkg
          type: uni
          act: rcv
          width: 1
          default: lc_ctrl_pkg::Off
          inst_name: rv_dm
          domain: Main
          top_signame: lc_ctrl_lc_init_done
          index: -1
        }
        {
          name: lc_hw_debug_clr
          desc:
            '''
            Multibit life cycle hardware debug clear signal coming from life cycle controller,
            asserted when the hardware debug mechanism was enabled and gets disabled.
            '''
          struct: lc_tx
          package: lc_ctrl_pkg
          type: uni
          act: rcv
          width: 1
          default: lc_ctrl_pkg::Off
          inst_name: rv_dm
          domain: Main
          top_signame: lc_ctrl_lc_hw_debug_clr
          index: -1
        }
        {
          name: lc_hw_debug_en
          desc:
            '''
            Multibit life cycle hardware debug enable signal coming from life cycle controller,
            asserted when the hardware debug mechanisms are enabled in the system.
            '''
          struct: lc_tx
          package: lc_ctrl_pkg
          type: uni
          act: rcv
          width: 1
          default: lc_ctrl_pkg::Off
          inst_name: rv_dm
          domain: Main
          top_signame: lc_ctrl_lc_hw_debug_en
          index: -1
        }
        {
          name: lc_dft_en
          desc:
            '''
            Multibit life cycle hardware debug enable signal coming from life cycle controller,
            asserted when the DFT mechanisms are enabled in the system.
            '''
          struct: lc_tx
          package: lc_ctrl_pkg
          type: uni
          act: rcv
          width: 1
          default: lc_ctrl_pkg::Off
          inst_name: rv_dm
          domain: Main
          top_signame: lc_ctrl_lc_dft_en
          index: -1
        }
        {
          name: pinmux_hw_debug_en
          desc:
            '''
            Multibit life cycle hardware debug enable signal coming from pinmux.
            This is a latched version of the lc_hw_debug_en signal and is only used to
            gate the JTAG / TAP side of the RV_DM. It is used to keep a debug session live
            while the rest of the system undergoes an NDM reset.
            '''
          struct: lc_tx
          package: lc_ctrl_pkg
          type: uni
          act: rcv
          width: 1
          default: lc_ctrl_pkg::Off
          inst_name: rv_dm
          domain: Main
          top_signame: pinmux_pinmux_hw_debug_en
          index: -1
          external: true
          conn_type: false
        }
        {
          name: otp_dis_rv_dm_late_debug
          struct: mubi8
          package: prim_mubi_pkg
          type: uni
          act: rcv
          width: 1
          default: prim_mubi_pkg::MuBi8False
          inst_name: rv_dm
          top_signame: rv_dm_otp_dis_rv_dm_late_debug
          index: -1
        }
        {
          name: unavailable
          desc:
            '''
            This signal indicates to the debug module that the main processor is not available
            for debug (e.g. due to a low-power state).
            '''
          struct: logic
          type: uni
          act: rcv
          width: 1
          default: 1'b0
          inst_name: rv_dm
          index: -1
        }
        {
          name: ndmreset_req
          desc: Non-debug module reset request going to the system reset infrastructure.
          struct: logic
          type: uni
          act: req
          width: 1
          inst_name: rv_dm
          default: ""
          package: ""
          end_idx: -1
          top_type: broadcast
          top_signame: rv_dm_ndmreset_req
          index: -1
          external: true
          conn_type: false
        }
        {
          name: dmactive
          desc:
            '''
            This signal indicates whether the debug module is active and can be used to prevent
            power down of the core and bus-attached peripherals.
            '''
          struct: logic
          type: uni
          act: req
          width: 1
          inst_name: rv_dm
          index: -1
        }
        {
          name: debug_req
          desc: This is the debug request interrupt going to the main processor.
          struct: logic [rv_dm_reg_pkg::NrHarts-1:0]
          type: uni
          act: req
          width: 1
          inst_name: rv_dm
          default: ""
          package: ""
          end_idx: -1
          top_type: broadcast
          top_signame: rv_dm_debug_req
          index: -1
        }
        {
          name: lc_escalate_en
          desc:
            '''
            Escalation enable signal coming from life cycle controller, used for invalidating
            the latched lc_hw_debug_en state inside the strap sampling logic.
            '''
          struct: lc_tx
          package: lc_ctrl_pkg
          type: uni
          act: rcv
          width: 1
          default: lc_ctrl_pkg::Off
          inst_name: rv_dm
          index: -1
        }
        {
          name: lc_check_byp_en
          desc:
            '''
            Check bypass enable signal coming from life cycle controller, used for invalidating
            the latched lc_hw_debug_en state inside the strap sampling logic. This signal is asserted
            whenever the life cycle controller performs a life cycle transition. Its main use is
            to skip any background checks inside the life cycle partition of the OTP controller while
            a life cycle transition is in progress.
            '''
          struct: lc_tx
          package: lc_ctrl_pkg
          type: uni
          act: rcv
          width: 1
          default: lc_ctrl_pkg::Off
          inst_name: rv_dm
          index: -1
        }
        {
          name: strap_en
          desc: This signal is pulsed high by the power manager after reset in order to sample the HW straps.
          struct: logic
          type: uni
          act: rcv
          width: 1
          default: 1'b0
          inst_name: rv_dm
          index: -1
        }
        {
          name: strap_en_override
          desc:
            '''
            This signal transitions from 0 -> 1 by the lc_ctrl manager after volatile RAW_UNLOCK in order to re-sample the HW straps.
            The signal must stay at 1 until reset.
            Note that this is only used in test chips when SecVolatileRawUnlockEn = 1.
            Otherwise this signal is unused.
            '''
          struct: logic
          type: uni
          act: rcv
          width: 1
          default: 1'b0
          inst_name: rv_dm
          index: -1
        }
        {
          name: racl_policies
          desc:
            '''
            Incoming RACL policy vector from a racl_ctrl instance.
            The policy selection vector (parameter) selects the policy for each register.
            '''
          struct: racl_policy_vec
          package: top_racl_pkg
          type: uni
          act: rcv
          width: 1
          inst_name: rv_dm
          index: -1
        }
        {
          name: racl_error
          desc: RACL error log information of this module.
          struct: racl_error_log
          package: top_racl_pkg
          type: uni
          act: req
          width: 1
          inst_name: rv_dm
          index: -1
        }
        {
          name: sba_tl_h
          struct: tl
          package: tlul_pkg
          type: req_rsp
          act: req
          width: 1
          inst_name: rv_dm
          default: ""
          domain: Main
          top_signame: main_tl_rv_dm__sba
          index: -1
        }
        {
          name: regs_tl_d
          struct: tl
          package: tlul_pkg
          type: req_rsp
          act: rsp
          width: 1
          inst_name: rv_dm
          default: ""
          end_idx: -1
          top_type: one-to-one
          top_signame: rv_dm_regs_tl_d
          index: -1
        }
        {
          name: mem_tl_d
          struct: tl
          package: tlul_pkg
          type: req_rsp
          act: rsp
          width: 1
          inst_name: rv_dm
          default: ""
          end_idx: -1
          top_type: one-to-one
          top_signame: rv_dm_mem_tl_d
          index: -1
        }
        {
          name: dbg_tl_d
          struct: tl
          package: tlul_pkg
          type: req_rsp
          act: rsp
          width: 1
          inst_name: rv_dm
          index: -1
        }
      ]
    }
    {
      name: rv_plic
      type: rv_plic
      template_type: rv_plic
      clock_srcs:
      {
        clk_i: main
      }
      clock_group: secure
      reset_connections:
      {
        rst_ni:
        {
          name: lc
          domain: Main
        }
      }
      attr: ipgen
      targets:
      [
        rv_core_ibex
      ]
      domain: Main
      clock_connections:
      {
        clk_i: clkmgr_clocks_i.clk_main_secure
      }
      param_decl: {}
      memory: {}
      param_list: []
      inter_signal_list:
      [
        {
          name: irq
          struct: logic
          type: uni
          act: req
          width: 1
          inst_name: rv_plic
          default: ""
          package: ""
          end_idx: -1
          top_type: broadcast
          top_signame: rv_plic_irq
          index: -1
        }
        {
          name: irq_id
          struct: logic
          type: uni
          act: req
          width: 1
          inst_name: rv_plic
          index: -1
        }
        {
          name: msip
          struct: logic
          type: uni
          act: req
          width: 1
          inst_name: rv_plic
          default: ""
          package: ""
          end_idx: -1
          top_type: broadcast
          top_signame: rv_plic_msip
          index: -1
        }
        {
          name: tl
          struct: tl
          package: tlul_pkg
          type: req_rsp
          act: rsp
          width: 1
          inst_name: rv_plic
          default: ""
          end_idx: -1
          top_type: one-to-one
          top_signame: rv_plic_tl
          index: -1
        }
      ]
      base_addrs:
      {
        null:
        {
          hart: 0x48000000
        }
      }
      generate_dif: true
    }
    {
      name: aes
      type: aes
      clock_srcs:
      {
        clk_i: main
        clk_edn_i: main
      }
      clock_group: trans
      reset_connections:
      {
        rst_ni:
        {
          name: lc
          domain: Main
        }
        rst_edn_ni:
        {
          name: lc
          domain: Main
        }
      }
      param_decl:
      {
        AESGCMEnable: "0"
        SecMasking: "1"
        SecSBoxImpl: aes_pkg::SBoxImplDom
      }
      domain: Main
      clock_connections:
      {
        clk_i: clkmgr_clocks_i.clk_main_aes
        clk_edn_i: clkmgr_clocks_i.clk_main_aes
      }
      memory: {}
      param_list:
      [
        {
          name: AES192Enable
          desc: Disable (0) or enable (1) support for 192-bit key lengths (AES-192).
          type: bit
          default: 1'b1
          local: "false"
          expose: "false"
          name_top: AesAES192Enable
        }
        {
          name: AESGCMEnable
          desc: Disable (0) or enable (1) support for Galois/Counter Mode (GCM) in hardware.
          type: bit
          default: "0"
          local: "false"
          expose: "true"
          name_top: AesAESGCMEnable
        }
        {
          name: SecMasking
          desc:
            '''
            Disable (0) or enable (1) first-order masking of the AES cipher core and the GHASH operation of GCM.
            Masking requires the use of a masked S-Box, see SecSBoxImpl parameter.
            '''
          type: bit
          default: "1"
          local: "false"
          expose: "true"
          name_top: SecAesMasking
        }
        {
          name: SecSBoxImpl
          desc: Selection of the S-Box implementation. See aes_pkg.sv.
          type: aes_pkg::sbox_impl_e
          default: aes_pkg::SBoxImplDom
          local: "false"
          expose: "true"
          name_top: SecAesSBoxImpl
        }
        {
          name: SecStartTriggerDelay
          desc:
            '''
            Manual start trigger delay, useful for SCA measurements.
            A value of e.g. 40 allows the processor to go into sleep before AES starts operation.
            '''
          type: int unsigned
          default: "0"
          local: "false"
          expose: "true"
          name_top: SecAesStartTriggerDelay
        }
        {
          name: SecAllowForcingMasks
          desc:
            '''
            Forbid (0) or allow (1) forcing the masking PRNG output to a constant value via FORCE_MASKS bit in the Auxiliary Control Register.
            Useful for SCA measurements.
            Meaningful only if masking is enabled.
            '''
          type: bit
          default: 1'b0
          local: "false"
          expose: "true"
          name_top: SecAesAllowForcingMasks
        }
        {
          name: SecSkipPRNGReseeding
          desc:
            '''
            Perform (0) or skip (1) PRNG reseeding requests, useful for SCA measurements only.
            The current SCA setup doesn't provide sufficient resources to implement the infrastructure required for PRNG reseeding (CSRNG, EDN).
            To enable SCA resistance evaluations, we need to skip reseeding requests on the SCA platform.
            '''
          type: bit
          default: 1'b0
          local: "false"
          expose: "true"
          name_top: SecAesSkipPRNGReseeding
        }
      ]
      inter_signal_list:
      [
        {
          name: idle
          struct: mubi4
          package: prim_mubi_pkg
          type: uni
          act: req
          width: 1
          inst_name: aes
          default: ""
          domain: Main
          top_signame: clkmgr_idle
          index: 0
          external: true
          conn_type: false
        }
        {
          name: output_valid
          struct: logic
          type: uni
          act: req
          width: 1
          inst_name: aes
          index: -1
        }
        {
          name: input_ready
          struct: logic
          type: uni
          act: req
          width: 1
          inst_name: aes
          index: -1
        }
        {
          name: lc_escalate_en
          struct: lc_tx
          package: lc_ctrl_pkg
          type: uni
          act: rcv
          width: 1
          default: lc_ctrl_pkg::Off
          inst_name: aes
          domain: Main
          top_signame: lc_ctrl_lc_escalate_en
          index: -1
        }
        {
          name: edn
          struct: edn
          package: edn_pkg
          type: req_rsp
          act: req
          width: 1
          inst_name: aes
          default: ""
          domain: Main
          top_signame: edn0_edn
          index: 5
        }
        {
          name: keymgr_key
          struct: hw_key_req
          package: keymgr_dpe_pkg
          type: uni
          act: rcv
          width: 1
          inst_name: aes
          default: ""
          domain: Main
          top_signame: keymgr_dpe_aes_key
          index: -1
        }
        {
          name: tl
          struct: tl
          package: tlul_pkg
          type: req_rsp
          act: rsp
          width: 1
          inst_name: aes
          default: ""
          end_idx: -1
          top_type: one-to-one
          top_signame: aes_tl
          index: -1
        }
      ]
      base_addrs:
      {
        null:
        {
          hart: 0x41100000
        }
      }
      generate_dif: true
    }
    {
      name: hmac
      type: hmac
      clock_srcs:
      {
        clk_i: main
      }
      clock_group: trans
      reset_connections:
      {
        rst_ni:
        {
          name: lc
          domain: Main
        }
      }
      domain: Main
      clock_connections:
      {
        clk_i: clkmgr_clocks_i.clk_main_hmac
      }
      param_decl: {}
      memory: {}
      param_list: []
      inter_signal_list:
      [
        {
          name: idle
          struct: mubi4
          package: prim_mubi_pkg
          type: uni
          act: req
          width: 1
          inst_name: hmac
          default: ""
          domain: Main
          top_signame: clkmgr_idle
          index: 1
          external: true
          conn_type: false
        }
        {
          name: keymgr_key
          struct: wide_hw_key_req
          package: keymgr_dpe_pkg
          type: uni
          act: rcv
          width: 1
          inst_name: hmac
          default: ""
          domain: Main
          top_signame: keymgr_dpe_hmac_key
          index: -1
        }
        {
          name: tl
          struct: tl
          package: tlul_pkg
          type: req_rsp
          act: rsp
          width: 1
          inst_name: hmac
          default: ""
          end_idx: -1
          top_type: one-to-one
          top_signame: hmac_tl
          index: -1
        }
      ]
      base_addrs:
      {
        null:
        {
          hart: 0x41110000
        }
      }
      generate_dif: true
    }
    {
      name: kmac
      type: kmac
      param_decl:
      {
        EnMasking: "1"
      }
      clock_srcs:
      {
        clk_i: main
        clk_edn_i: main
      }
      clock_group: trans
      reset_connections:
      {
        rst_ni:
        {
          name: lc
          domain: Main
        }
        rst_edn_ni:
        {
          name: lc
          domain: Main
        }
      }
      domain: Main
      clock_connections:
      {
        clk_i: clkmgr_clocks_i.clk_main_kmac
        clk_edn_i: clkmgr_clocks_i.clk_main_kmac
      }
      memory: {}
      param_list:
      [
        {
          name: EnMasking
          desc: Disable(0) or enable(1) first-order masking of Keccak round.
          type: bit
          default: "1"
          local: "false"
          expose: "true"
          name_top: KmacEnMasking
        }
        {
          name: EnFullKmac
          desc:
            '''
            Disable(0) or enable(1) the full KMAC functionality.
            If disabled, the module is stripped down to only support SHA3, SHAKE and cSHAKE.
            '''
          type: bit
          default: "1"
          local: "false"
          expose: "true"
          name_top: KmacEnFullKmac
        }
        {
          name: SwKeyMasked
          desc:
            '''
            Disable(0) or enable(1) software key masking in case masking is disabled (EnMasking == 0).
            If masking is enabled, this parameter has no effect.
            Mainly useful for software interface compatibility between the masked and unmasked design.
            Mostly relevant for SCA measurements.
            '''
          type: bit
          default: "0"
          local: "false"
          expose: "true"
          name_top: KmacSwKeyMasked
        }
        {
          name: SecCmdDelay
          desc:
            '''
            Command delay, useful for SCA measurements only.
            A value of e.g. 40 allows the processor to go into sleep before KMAC starts operation.
            If a value greater than 0 is chosen, software can pass two commands in series.
            The second command is buffered internally and will be presented to the hardware SecCmdDelay number of cycles after the first one.
            '''
          type: int
          default: "0"
          local: "false"
          expose: "true"
          name_top: SecKmacCmdDelay
        }
        {
          name: SecIdleAcceptSwMsg
          desc:
            '''
            If enabled (1), software writes to the message FIFO before having received a START command are not ignored.
            Disabled (0) by default.
            Useful for SCA measurements only.
            '''
          type: bit
          default: "0"
          local: "false"
          expose: "true"
          name_top: SecKmacIdleAcceptSwMsg
        }
        {
          name: NumAppIntf
          desc: Number of application interfaces
          type: int
          default: 4
          local: "false"
          expose: "true"
          name_top: KmacNumAppIntf
        }
        {
          name: AppCfg
          desc:
            '''
            Application interface configuration.
            Top-level connection to the application interface must follow this definition.
            '''
          type: kmac_pkg::app_config_t
          unpacked_dimensions: "[KmacNumAppIntf]"
          default: "'{kmac_pkg::AppCfgKeyMgr, kmac_pkg::AppCfgLcCtrl, kmac_pkg::AppCfgRomCtrl, kmac_pkg::AppCfgOtbn}"
          local: "false"
          expose: "true"
          name_top: KmacAppCfg
        }
      ]
      inter_signal_list:
      [
        {
          name: keymgr_key
          struct: hw_key_req
          package: keymgr_dpe_pkg
          type: uni
          act: rcv
          width: 1
          inst_name: kmac
          default: ""
          domain: Main
          top_signame: keymgr_dpe_kmac_key
          index: -1
        }
        {
          name: app
          struct: app
          package: kmac_pkg
          type: req_rsp
          act: rsp
          width:
          {
            name: NumAppIntf
            desc: Number of application interfaces
            param_type: int
            unpacked_dimensions: null
            default: 4
            local: false
            expose: true
            name_top: KmacNumAppIntf
          }
          default: kmac_pkg::APP_REQ_DEFAULT
          inst_name: kmac
          end_idx: -1
          top_type: one-to-N
          top_signame: kmac_app
          index: -1
        }
        {
          name: entropy
          struct: edn
          package: edn_pkg
          type: req_rsp
          act: req
          width: 1
          inst_name: kmac
          default: ""
          domain: Main
          top_signame: edn0_edn
          index: 3
        }
        {
          name: idle
          struct: mubi4
          package: prim_mubi_pkg
          type: uni
          act: req
          width: 1
          inst_name: kmac
          default: ""
          domain: Main
          top_signame: clkmgr_idle
          index: 2
          external: true
          conn_type: false
        }
        {
          name: en_masking
          struct: logic
          type: uni
          act: req
          width: 1
          inst_name: kmac
          default: ""
          package: ""
          end_idx: -1
          top_type: broadcast
          top_signame: kmac_en_masking
          index: -1
        }
        {
          name: lc_escalate_en
          struct: lc_tx
          package: lc_ctrl_pkg
          type: uni
          act: rcv
          width: 1
          default: lc_ctrl_pkg::Off
          inst_name: kmac
          domain: Main
          top_signame: lc_ctrl_lc_escalate_en
          index: -1
        }
        {
          name: tl
          struct: tl
          package: tlul_pkg
          type: req_rsp
          act: rsp
          width: 1
          inst_name: kmac
          default: ""
          end_idx: -1
          top_type: one-to-one
          top_signame: kmac_tl
          index: -1
        }
      ]
      base_addrs:
      {
        null:
        {
          hart: 0x41120000
        }
      }
      generate_dif: true
    }
    {
      name: otbn
      type: otbn
      clock_srcs:
      {
        clk_i:
        {
          clock: main
          group: trans
        }
        clk_edn_i:
        {
          clock: main
          group: secure
        }
        clk_otp_i:
        {
          clock: io_div4
          group: secure
        }
      }
      clock_group: trans
      reset_connections:
      {
        rst_ni:
        {
          name: lc
          domain: Main
        }
        rst_edn_ni:
        {
          name: lc
          domain: Main
        }
        rst_otp_ni:
        {
          name: lc_io_div4
          domain: Main
        }
      }
      domain: Main
      clock_connections:
      {
        clk_i: clkmgr_clocks_i.clk_main_otbn
        clk_edn_i: clkmgr_clocks_i.clk_main_secure
        clk_otp_i: clkmgr_clocks_i.clk_io_div4_secure
      }
      param_decl: {}
      memory: {}
      param_list:
      [
        {
          name: Stub
          desc: Stub out the core of Otbn logic
          type: bit
          default: "0"
          local: "false"
          expose: "true"
          name_top: OtbnStub
        }
        {
          name: RegFile
          desc: Selection of the register file implementation. See otbn_pkg.sv.
          type: otbn_pkg::regfile_e
          default: otbn_pkg::RegFileFF
          local: "false"
          expose: "true"
          name_top: OtbnRegFile
        }
        {
          name: SecFixMaiOpSeq
          desc:
            '''
            If enabled (1), masking accelerator interface will not randomize operand start indexes.
            Disabled (0) by default.
            Useful for SCA measurements only.
            '''
          type: bit
          default: "0"
          local: "false"
          expose: "true"
          name_top: SecOtbnFixMaiOpSeq
        }
        {
          name: SecFixMacOpSeq
          desc:
            '''
            If enabled (1), the BN MAC will not randomize the order in which the vector elements are processed for vectorized multiplication instructions.
            Disabled (0) by default.
            Useful for SCA measurements only.
            '''
          type: bit
          default: "0"
          local: "false"
          expose: "true"
          name_top: SecOtbnFixMacOpSeq
        }
        {
          name: SecSkipUrndReseedAtStart
          desc:
            '''
            If enabled (1), URND reseed is skipped at the start of an operation.
            Disabled (0) by default.
            Useful for SCA measurements only.
            '''
          type: bit
          default: "0"
          local: "false"
          expose: "true"
          name_top: SecOtbnSkipUrndReseedAtStart
        }
        {
          name: FeatStubMai
          desc:
            '''
            If enabled (1), MAI and mask accelerator are not preset in the design.
            Disabled (0) by default.
            Useful for resource-bound targets only. Can break software setups and DV.
            '''
          type: bit
          default: "0"
          local: "false"
          expose: "true"
          name_top: OtbnFeatStubMai
        }
      ]
      inter_signal_list:
      [
        {
          name: otbn_otp_key
          struct: otbn_otp_key
          package: otp_ctrl_pkg
          type: req_rsp
          act: req
          width: 1
          default: "'0"
          inst_name: otbn
          domain: Main
          top_signame: otp_ctrl_otbn_otp_key
          index: -1
        }
        {
          name: edn_rnd
          struct: edn
          package: edn_pkg
          type: req_rsp
          act: req
          width: 1
          inst_name: otbn
          default: ""
          domain: Main
          top_signame: edn1_edn
          index: 0
        }
        {
          name: edn_urnd
          struct: edn
          package: edn_pkg
          type: req_rsp
          act: req
          width: 1
          inst_name: otbn
          default: ""
          domain: Main
          top_signame: edn0_edn
          index: 6
        }
        {
          name: idle
          struct: mubi4
          package: prim_mubi_pkg
          type: uni
          act: req
          width: 1
          inst_name: otbn
          default: ""
          domain: Main
          top_signame: clkmgr_idle
          index: 3
          external: true
          conn_type: false
        }
        {
          name: ram_cfg_imem
          struct: ram_1p_cfg
          package: prim_ram_1p_pkg
          type: req_rsp
          act: rsp
          width: 1
          inst_name: otbn
          default: ""
          top_signame: otbn_ram_cfg_imem
          index: -1
        }
        {
          name: ram_cfg_dmem
          struct: ram_1p_cfg
          package: prim_ram_1p_pkg
          type: req_rsp
          act: rsp
          width: 1
          inst_name: otbn
          default: ""
          top_signame: otbn_ram_cfg_dmem
          index: -1
        }
        {
          name: lc_escalate_en
          struct: lc_tx
          package: lc_ctrl_pkg
          type: uni
          act: rcv
          width: 1
          default: lc_ctrl_pkg::Off
          inst_name: otbn
          domain: Main
          top_signame: lc_ctrl_lc_escalate_en
          index: -1
        }
        {
          name: lc_rma_req
          struct: lc_tx
          package: lc_ctrl_pkg
          type: uni
          act: rcv
          width: 1
          default: lc_ctrl_pkg::Off
          inst_name: otbn
          domain: Main
          top_signame: lc_ctrl_lc_nvm_rma_req
          index: -1
        }
        {
          name: lc_rma_ack
          struct: lc_tx
          package: lc_ctrl_pkg
          type: uni
          act: req
          width: 1
          default: lc_ctrl_pkg::Off
          inst_name: otbn
          domain: Main
          top_signame: lc_ctrl_lc_nvm_rma_ack
          index: 1
        }
        {
          name: keymgr_key
          struct: wide_hw_key_req
          package: keymgr_dpe_pkg
          type: uni
          act: rcv
          width: 1
          inst_name: otbn
          default: ""
          domain: Main
          top_signame: keymgr_dpe_otbn_key
          index: -1
        }
        {
          name: kmac_app
          struct: app
          package: kmac_pkg
          type: req_rsp
          act: req
          width: 1
          inst_name: otbn
          default: ""
          domain: Main
          top_signame: kmac_app
          index: 3
        }
        {
          name: keymgr_app
          struct: app
          package: kmac_pkg
          type: req_rsp
          act: rsp
          width: 1
          inst_name: otbn
          default: ""
          end_idx: -1
          top_type: one-to-one
          top_signame: otbn_keymgr_app
          index: -1
        }
        {
          name: keymgr_sensitive_key
          struct: mubi4
          package: prim_mubi_pkg
          type: uni
          act: rcv
          width: 1
          default: prim_mubi_pkg::MuBi4False
          inst_name: otbn
          end_idx: -1
          top_type: broadcast
          top_signame: otbn_keymgr_sensitive_key
          index: -1
        }
        {
          name: tl
          struct: tl
          package: tlul_pkg
          type: req_rsp
          act: rsp
          width: 1
          inst_name: otbn
          default: ""
          end_idx: -1
          top_type: one-to-one
          top_signame: otbn_tl
          index: -1
        }
      ]
      base_addrs:
      {
        null:
        {
          hart: 0x41130000
        }
      }
      generate_dif: true
    }
    {
      name: keymgr_dpe
      type: keymgr_dpe
      clock_srcs:
      {
        clk_i: main
        clk_edn_i: main
      }
      clock_group: secure
      reset_connections:
      {
        rst_ni:
        {
          name: lc
          domain: Main
        }
        rst_edn_ni:
        {
          name: lc
          domain: Main
        }
      }
      param_decl:
      {
        NumInstHwSlot: "4"
        NumBootStages: "4"
        NumRomDigestInputs: "1"
        KdfEngineSel: keymgr_dpe_pkg::KdfEngineBoth
      }
      domain: Main
      clock_connections:
      {
        clk_i: clkmgr_clocks_i.clk_main_secure
        clk_edn_i: clkmgr_clocks_i.clk_main_secure
      }
      memory: {}
      param_list:
      [
        {
          name: KmacEnMasking
          desc: Flag indicating with kmac masking is enabled
          type: bit
          default: "1"
          local: "false"
          expose: "true"
          name_top: KeymgrDpeKmacEnMasking
        }
        {
          name: NumInstHwSlot
          desc: Number of instantiated HW slots
          type: int
          default: "4"
          local: "true"
          expose: "true"
          name_top: KeymgrDpeNumInstHwSlot
        }
        {
          name: NumBootStages
          desc: Number of available boot stages. Supported values are 2 and 4.
          type: int
          default: "4"
          local: "true"
          expose: "true"
          name_top: KeymgrDpeNumBootStages
        }
        {
          name: NumRomDigestInputs
          desc: Number of digest inputs from ROM_CTRL
          type: int
          default: "1"
          local: "true"
          expose: "true"
          name_top: KeymgrDpeNumRomDigestInputs
        }
        {
          name: KdfEngineSel
          desc:
            '''
            Determines the possible KDF engines for the keymgr_dpe.
            Supported options are:
            - KdfEngineKmac: Uses exclusively `kmac` as kdf engine.
            - KdfEngineOtbn: Uses exclusively `otbn` as kdf engine.
            - KdfEngineBoth: The register !!KDF_ENGINE_SHADOWED selects if either the `kmac` or the `otbn` is used.
            '''
          type: keymgr_dpe_pkg::kdf_engine_sel_e
          default: keymgr_dpe_pkg::KdfEngineBoth
          local: "true"
          expose: "true"
          name_top: KeymgrDpeKdfEngineSel
        }
      ]
      inter_signal_list:
      [
        {
          name: edn
          struct: edn
          package: edn_pkg
          type: req_rsp
          act: req
          width: 1
          inst_name: keymgr_dpe
          default: ""
          domain: Main
          top_signame: edn0_edn
          index: 0
        }
        {
          name: aes_key
          struct: hw_key_req
          package: keymgr_dpe_pkg
          type: uni
          act: req
          width: 1
          inst_name: keymgr_dpe
          default: ""
          end_idx: -1
          top_type: broadcast
          top_signame: keymgr_dpe_aes_key
          index: -1
        }
        {
          name: kmac_key
          struct: hw_key_req
          package: keymgr_dpe_pkg
          type: uni
          act: req
          width: 1
          inst_name: keymgr_dpe
          default: ""
          end_idx: -1
          top_type: broadcast
          top_signame: keymgr_dpe_kmac_key
          index: -1
        }
        {
          name: hmac_key
          struct: wide_hw_key_req
          package: keymgr_dpe_pkg
          type: uni
          act: req
          width: 1
          inst_name: keymgr_dpe
          default: ""
          end_idx: -1
          top_type: broadcast
          top_signame: keymgr_dpe_hmac_key
          index: -1
        }
        {
          name: otbn_key
          struct: wide_hw_key_req
          package: keymgr_dpe_pkg
          type: uni
          act: req
          width: 1
          inst_name: keymgr_dpe
          default: ""
          end_idx: -1
          top_type: broadcast
          top_signame: keymgr_dpe_otbn_key
          index: -1
        }
        {
          name: kmac_app
          struct: app
          package: kmac_pkg
          type: req_rsp
          act: req
          width: 1
          inst_name: keymgr_dpe
          default: ""
          domain: Main
          top_signame: kmac_app
          index: 0
        }
        {
          name: otbn_app
          struct: app
          package: kmac_pkg
          type: req_rsp
          act: req
          width: 1
          inst_name: keymgr_dpe
          default: ""
          domain: Main
          top_signame: otbn_keymgr_app
          index: -1
        }
        {
          name: sensitive_key
          struct: mubi4
          package: prim_mubi_pkg
          type: uni
          act: req
          width: 1
          default: prim_mubi_pkg::MuBi4False
          inst_name: keymgr_dpe
          domain: Main
          top_signame: otbn_keymgr_sensitive_key
          index: -1
        }
        {
          name: creator_root_key
          struct: keymgr_dpe_creator_root_key
          package: keymgr_dpe_pkg
          type: uni
          act: rcv
          width: 1
          inst_name: keymgr_dpe
          default: ""
          domain: Main
          top_signame: otp_ctrl_keymgr_creator_root_key
          index: -1
        }
        {
          name: secondary_root_key
          struct: keymgr_dpe_creator_root_key
          package: keymgr_dpe_pkg
          type: uni
          act: rcv
          width: 1
          default: keymgr_dpe_pkg::KEYMGR_DPE_SECONDARY_ROOT_KEY_DEFAULT
          inst_name: keymgr_dpe
          index: -1
        }
        {
          name: creator_seed
          struct: keymgr_dpe_creator_seed
          package: keymgr_dpe_pkg
          type: uni
          act: rcv
          width: 1
          inst_name: keymgr_dpe
          default: ""
          domain: Main
          top_signame: rram_ctrl_keymgr_creator_seed
          index: -1
        }
        {
          name: owner_seed
          struct: keymgr_dpe_owner_seed
          package: keymgr_dpe_pkg
          type: uni
          act: rcv
          width: 1
          inst_name: keymgr_dpe
          default: ""
          domain: Main
          top_signame: rram_ctrl_keymgr_owner_seed
          index: -1
        }
        {
          name: device_id
          struct: keymgr_dpe_device_id
          package: keymgr_dpe_pkg
          type: uni
          act: rcv
          width: 1
          inst_name: keymgr_dpe
          default: ""
          top_signame: keymgr_dpe_device_id
          index: -1
        }
        {
          name: field_entropy
          struct: keymgr_dpe_field_entropy
          package: keymgr_dpe_pkg
          type: uni
          act: rcv
          width: 1
          inst_name: keymgr_dpe
          index: -1
        }
        {
          name: lc_keymgr_en
          struct: lc_tx
          package: lc_ctrl_pkg
          type: uni
          act: rcv
          width: 1
          default: lc_ctrl_pkg::On
          inst_name: keymgr_dpe
          domain: Main
          top_signame: lc_ctrl_lc_keymgr_en
          index: -1
        }
        {
          name: lc_keymgr_div
          struct: lc_keymgr_div
          package: lc_ctrl_pkg
          type: uni
          act: rcv
          width: 1
          inst_name: keymgr_dpe
          default: ""
          domain: Main
          top_signame: lc_ctrl_lc_keymgr_div
          index: -1
        }
        {
          name: rom_digest
          struct: keymgr_data
          package: rom_ctrl_pkg
          type: uni
          act: rcv
          width:
          {
            name: NumRomDigestInputs
            desc: Number of digest inputs from ROM_CTRL
            param_type: int
            unpacked_dimensions: null
            default: 1
            local: true
            expose: true
            name_top: KeymgrDpeNumRomDigestInputs
          }
          default: rom_ctrl_pkg::KEYMGR_DATA_DEFAULT
          inst_name: keymgr_dpe
          domain: Main
          top_signame: rom_ctrl_keymgr_data
          index: -1
        }
        {
          name: kmac_en_masking
          struct: logic
          type: uni
          act: rcv
          width: 1
          inst_name: keymgr_dpe
          default: ""
          package: ""
          domain: Main
          top_signame: kmac_en_masking
          index: -1
        }
        {
          name: tl
          struct: tl
          package: tlul_pkg
          type: req_rsp
          act: rsp
          width: 1
          inst_name: keymgr_dpe
          default: ""
          end_idx: -1
          top_type: one-to-one
          top_signame: keymgr_dpe_tl
          index: -1
        }
      ]
      base_addrs:
      {
        null:
        {
          hart: 0x41140000
        }
      }
      generate_dif: true
    }
    {
      name: csrng
      type: csrng
      clock_srcs:
      {
        clk_i: main
      }
      clock_group: secure
      reset_connections:
      {
        rst_ni:
        {
          name: lc
          domain: Main
        }
      }
      domain: Main
      clock_connections:
      {
        clk_i: clkmgr_clocks_i.clk_main_secure
      }
      param_decl: {}
      memory: {}
      param_list:
      [
        {
          name: SBoxImpl
          desc: Selection of the S-Box implementation. See aes_pkg.sv.
          type: aes_pkg::sbox_impl_e
          default: aes_pkg::SBoxImplCanright
          local: "false"
          expose: "true"
          name_top: CsrngSBoxImpl
        }
      ]
      inter_signal_list:
      [
        {
          name: csrng_cmd
          struct: csrng
          package: csrng_pkg
          type: req_rsp
          act: rsp
          width: 2
          inst_name: csrng
          default: ""
          end_idx: -1
          top_type: one-to-N
          top_signame: csrng_csrng_cmd
          index: -1
        }
        {
          name: entropy_src_hw_if
          struct: entropy_src_hw_if
          package: entropy_src_pkg
          type: req_rsp
          act: req
          width: 1
          inst_name: csrng
          default: ""
          end_idx: -1
          top_type: one-to-one
          top_signame: csrng_entropy_src_hw_if
          index: -1
        }
        {
          name: lc_hw_debug_en
          struct: lc_tx
          package: lc_ctrl_pkg
          type: uni
          act: rcv
          width: 1
          default: lc_ctrl_pkg::Off
          inst_name: csrng
          domain: Main
          top_signame: lc_ctrl_lc_hw_debug_en
          index: -1
        }
        {
          name: tl
          struct: tl
          package: tlul_pkg
          type: req_rsp
          act: rsp
          width: 1
          inst_name: csrng
          default: ""
          end_idx: -1
          top_type: one-to-one
          top_signame: csrng_tl
          index: -1
        }
      ]
      base_addrs:
      {
        null:
        {
          hart: 0x41150000
        }
      }
      generate_dif: true
    }
    {
      name: entropy_src
      type: entropy_src
      clock_srcs:
      {
        clk_i: main
      }
      clock_group: secure
      reset_connections:
      {
        rst_ni:
        {
          name: lc
          domain: Main
        }
      }
      domain: Main
      clock_connections:
      {
        clk_i: clkmgr_clocks_i.clk_main_secure
      }
      param_decl: {}
      memory: {}
      param_list:
      [
        {
          name: RngBusWidth
          desc:
            '''
            Defines the bit-width of the noise source data.
            Must be between 4 and 256 (inclusive) and divisible by 4.
            The divisibility by 4 is a prerequisite for the bucket health test.
            '''
          type: int
          default: 4
          local: "false"
          expose: "true"
          name_top: EntropySrcRngBusWidth
        }
        {
          name: RngBusBitSelWidth
          desc: Explicit parameter defining the width of the RNG bit selection vector (log2(RngBusWidth))
          type: int
          default: 2
          local: "false"
          expose: "true"
          name_top: EntropySrcRngBusBitSelWidth
        }
        {
          name: HealthTestWindowWidth
          desc: Explicit parameter defining the width of the health test window (16 + log2(RngBusWidth))
          type: int
          default: 18
          local: "false"
          expose: "true"
          name_top: EntropySrcHealthTestWindowWidth
        }
        {
          name: EsFifoDepth
          desc: Number of 384-bit entries in the esfinal FIFO
          type: int
          default: "3"
          local: "true"
          expose: "true"
          name_top: EntropySrcEsFifoDepth
        }
        {
          name: DistrFifoDepth
          desc: Number of 32-bit entries in the distr FIFO
          type: int unsigned
          default: "3"
          local: "true"
          expose: "true"
          name_top: EntropySrcDistrFifoDepth
        }
        {
          name: Stub
          desc: Stub out the core of entropy_src logic
          type: bit
          default: "0"
          local: "false"
          expose: "true"
          name_top: EntropySrcStub
        }
      ]
      inter_signal_list:
      [
        {
          name: entropy_src_hw_if
          struct: entropy_src_hw_if
          package: entropy_src_pkg
          type: req_rsp
          act: rsp
          width: 1
          inst_name: entropy_src
          default: ""
          domain: Main
          top_signame: csrng_entropy_src_hw_if
          index: -1
        }
        {
          name: entropy_src_rng_enable
          desc:
            '''
            Signal through which entropy_src enables the noise source.
            entropy_src will keep this signal high as long as it expects the noise source to operate.
            This is *not* a flow control signal through which entropy_src would exert backpressure on the noise source; rather this signal stays high while entropy_src is enabled.
            '''
          struct: logic
          type: uni
          act: req
          width: 1
          inst_name: entropy_src
          default: ""
          package: ""
          end_idx: -1
          top_type: broadcast
          top_signame: entropy_src_entropy_src_rng_enable
          index: -1
        }
        {
          name: entropy_src_rng_valid
          desc:
            '''
            Acknowledgement signal from the noise source.
            When '1', it indicates that the `entropy_src_rng_bit` data is valid and ready to be consumed.
            '''
          struct: logic
          type: uni
          act: rcv
          width: 1
          inst_name: entropy_src
          default: ""
          package: ""
          domain: Main
          top_signame: ast_rng_val
          index: -1
        }
        {
          name: entropy_src_rng_bits
          desc:
            '''
            Output data bus carrying the raw entropy bits from the noise source.
            These bits are valid when `entropy_src_rng_valid` is asserted.
            The width is determined by `RngBusWidth` parametrization.
            '''
          struct: logic
          type: uni
          act: rcv
          width:
          {
            name: RngBusWidth
            desc:
              '''
              Defines the bit-width of the noise source data.
              Must be between 4 and 256 (inclusive) and divisible by 4.
              The divisibility by 4 is a prerequisite for the bucket health test.
              '''
            param_type: int
            unpacked_dimensions: null
            default: 4
            local: false
            expose: true
            name_top: EntropySrcRngBusWidth
          }
          inst_name: entropy_src
          default: ""
          package: ""
          domain: Main
          top_signame: ast_rng_b
          index: -1
        }
        {
          name: entropy_src_xht_valid
          desc:
            '''
            Valid signal for the external health test interface.
            When asserted, it indicates that `entropy_src_xht_bits`, `entropy_src_xht_bit_sel`, and `entropy_src_xht_meta` are valid for consumption by the external health test.
            '''
          struct: logic
          type: uni
          act: req
          width: 1
          inst_name: entropy_src
          index: -1
        }
        {
          name: entropy_src_xht_bits
          desc:
            '''
            Carries the raw entropy data from the entropy source to be consumed by the external health test module.
            The data on this bus is valid when `entropy_src_xht_valid` is asserted.
            The width is determined by `RngBusWidth` parametrization.
            '''
          struct: logic
          type: uni
          act: req
          width:
          {
            name: RngBusWidth
            desc:
              '''
              Defines the bit-width of the noise source data.
              Must be between 4 and 256 (inclusive) and divisible by 4.
              The divisibility by 4 is a prerequisite for the bucket health test.
              '''
            param_type: int
            unpacked_dimensions: null
            default: 4
            local: false
            expose: true
            name_top: EntropySrcRngBusWidth
          }
          inst_name: entropy_src
          index: -1
        }
        {
          name: entropy_src_xht_bit_sel
          desc:
            '''
            Provides bit selection information for the raw entropy data.
            It specifies which specific bit or subset of bits from `entropy_src_xht_bit` should be used.
            The width is determined by `RngBusBitSelWidth` parametrization.
            '''
          struct: logic
          type: uni
          act: req
          width:
          {
            name: RngBusBitSelWidth
            desc: Explicit parameter defining the width of the RNG bit selection vector (log2(RngBusWidth))
            param_type: int
            unpacked_dimensions: null
            default: 2
            local: false
            expose: true
            name_top: EntropySrcRngBusBitSelWidth
          }
          inst_name: entropy_src
          index: -1
        }
        {
          name: entropy_src_xht_health_test_window
          desc: Provides the window size of the health in bits.
          struct: logic
          type: uni
          act: req
          width:
          {
            name: HealthTestWindowWidth
            desc: Explicit parameter defining the width of the health test window (16 + log2(RngBusWidth))
            param_type: int
            unpacked_dimensions: null
            default: 18
            local: false
            expose: true
            name_top: EntropySrcHealthTestWindowWidth
          }
          inst_name: entropy_src
          index: -1
        }
        {
          name: entropy_src_xht_meta
          struct: entropy_src_xht_meta
          package: entropy_src_pkg
          type: req_rsp
          act: req
          width: 1
          inst_name: entropy_src
          index: -1
        }
        {
          name: rng_fips
          struct: logic
          type: uni
          act: req
          width: 1
          inst_name: entropy_src
          default: ""
          package: ""
          end_idx: -1
          top_type: broadcast
          top_signame: entropy_src_rng_fips
          index: -1
        }
        {
          name: tl
          struct: tl
          package: tlul_pkg
          type: req_rsp
          act: rsp
          width: 1
          inst_name: entropy_src
          default: ""
          end_idx: -1
          top_type: one-to-one
          top_signame: entropy_src_tl
          index: -1
        }
      ]
      base_addrs:
      {
        null:
        {
          hart: 0x41160000
        }
      }
      generate_dif: true
    }
    {
      name: edn0
      type: edn
      clock_srcs:
      {
        clk_i: main
      }
      clock_group: secure
      reset_connections:
      {
        rst_ni:
        {
          name: lc
          domain: Main
        }
      }
      param_decl:
      {
        NumEndPoints: "8"
      }
      domain: Main
      clock_connections:
      {
        clk_i: clkmgr_clocks_i.clk_main_secure
      }
      memory: {}
      param_list:
      [
        {
          name: NumEndPoints
          desc: Number of endpoints
          type: int unsigned
          default: "8"
          local: "true"
          expose: "true"
          name_top: Edn0NumEndPoints
        }
      ]
      inter_signal_list:
      [
        {
          name: csrng_cmd
          desc: EDN supports a single CSRNG application interface.
          struct: csrng
          package: csrng_pkg
          type: req_rsp
          act: req
          width: 1
          inst_name: edn0
          default: ""
          domain: Main
          top_signame: csrng_csrng_cmd
          index: 0
        }
        {
          name: edn
          desc: Every endpoint has its own peripheral port.
          struct: edn
          package: edn_pkg
          type: req_rsp
          act: rsp
          width:
          {
            name: NumEndPoints
            desc: Number of endpoints
            param_type: int unsigned
            unpacked_dimensions: null
            default: 8
            local: true
            expose: true
            name_top: Edn0NumEndPoints
          }
          default: "'0"
          inst_name: edn0
          end_idx: -1
          top_type: one-to-N
          top_signame: edn0_edn
          index: -1
        }
        {
          name: tl
          struct: tl
          package: tlul_pkg
          type: req_rsp
          act: rsp
          width: 1
          inst_name: edn0
          default: ""
          end_idx: -1
          top_type: one-to-one
          top_signame: edn0_tl
          index: -1
        }
      ]
      base_addrs:
      {
        null:
        {
          hart: 0x41170000
        }
      }
      generate_dif: true
    }
    {
      name: edn1
      type: edn
      clock_srcs:
      {
        clk_i: main
      }
      clock_group: secure
      reset_connections:
      {
        rst_ni:
        {
          name: lc
          domain: Main
        }
      }
      param_decl:
      {
        NumEndPoints: "1"
      }
      domain: Main
      clock_connections:
      {
        clk_i: clkmgr_clocks_i.clk_main_secure
      }
      memory: {}
      param_list:
      [
        {
          name: NumEndPoints
          desc: Number of endpoints
          type: int unsigned
          default: "1"
          local: "true"
          expose: "true"
          name_top: Edn1NumEndPoints
        }
      ]
      inter_signal_list:
      [
        {
          name: csrng_cmd
          desc: EDN supports a single CSRNG application interface.
          struct: csrng
          package: csrng_pkg
          type: req_rsp
          act: req
          width: 1
          inst_name: edn1
          default: ""
          domain: Main
          top_signame: csrng_csrng_cmd
          index: 1
        }
        {
          name: edn
          desc: Every endpoint has its own peripheral port.
          struct: edn
          package: edn_pkg
          type: req_rsp
          act: rsp
          width:
          {
            name: NumEndPoints
            desc: Number of endpoints
            param_type: int unsigned
            unpacked_dimensions: null
            default: 8
            local: true
            expose: true
            name_top: Edn1NumEndPoints
          }
          default: "'0"
          inst_name: edn1
          end_idx: -1
          top_type: one-to-one
          top_signame: edn1_edn
          index: -1
        }
        {
          name: tl
          struct: tl
          package: tlul_pkg
          type: req_rsp
          act: rsp
          width: 1
          inst_name: edn1
          default: ""
          end_idx: -1
          top_type: one-to-one
          top_signame: edn1_tl
          index: -1
        }
      ]
      base_addrs:
      {
        null:
        {
          hart: 0x41180000
        }
      }
      generate_dif: true
    }
    {
      name: sram_ctrl_main
      type: sram_ctrl
      clock_srcs:
      {
        clk_i: main
        clk_otp_i: io_div4
      }
      clock_group: infra
      reset_connections:
      {
        rst_ni:
        {
          name: lc
          domain: Main
        }
        rst_otp_ni:
        {
          name: lc_io_div4
          domain: Main
        }
      }
      param_decl:
      {
        InstrExec: "1"
        NumPrinceRoundsHalf: "2"
        InstSize: "131072"
      }
      base_addrs:
      {
        regs:
        {
          hart: 0x411C0000
        }
        ram:
        {
          hart: 0x10000000
        }
      }
      memory:
      {
        ram:
        {
          label: ram_main
          swaccess: rw
          data_intg_passthru: "true"
          exec: True
          byte_write: True
          size: 0x20000
        }
      }
      domain: Main
      clock_connections:
      {
        clk_i: clkmgr_clocks_i.clk_main_infra
        clk_otp_i: clkmgr_clocks_i.clk_io_div4_infra
      }
      param_list:
      [
        {
          name: MemSizeRam
          desc:
            '''
            Memory size of the RAM (in bytes).
            If address scrambling is enabled, this must be a power of 2 or a multiple of 16 KiB.
            For details, check the SRAM scrambling primitive (prim_ram_1p_scr).
            '''
          type: int
          name_top: MemSizeSramCtrlMainRam
          default: 131072
        }
        {
          name: InstSize
          desc: Memory size of a single RAM tile (in bytes).
          type: int
          default: "131072"
          local: "false"
          expose: "true"
          name_top: SramCtrlMainInstSize
        }
        {
          name: NumRamInst
          desc: Number of internal RAM instances. Must be the same as ceil(MemSizeRam / InstSize) .
          type: int
          default: 1
          local: "false"
          expose: "true"
          name_top: SramCtrlMainNumRamInst
        }
        {
          name: InstrExec
          desc: Support execution from SRAM
          type: bit
          default: "1"
          local: "false"
          expose: "true"
          name_top: SramCtrlMainInstrExec
        }
        {
          name: NumPrinceRoundsHalf
          desc: Number of PRINCE half rounds for the SRAM scrambling feature
          type: int
          default: "2"
          local: "false"
          expose: "true"
          name_top: SramCtrlMainNumPrinceRoundsHalf
        }
        {
          name: NumAddrScrRounds
          desc: Number of address scrambling rounds. 0 disables address scrambling.
          type: int
          default: "2"
          local: "false"
          expose: "true"
          name_top: SramCtrlMainNumAddrScrRounds
        }
        {
          name: Outstanding
          desc: Number of outstanding TLUL transactions
          type: int
          default: "2"
          local: "true"
          expose: "true"
          name_top: SramCtrlMainOutstanding
        }
        {
          name: EccCorrection
          desc: Enable single-bit error correction and error logging
          type: bit
          default: "0"
          local: "false"
          expose: "true"
          name_top: SramCtrlMainEccCorrection
        }
        {
          name: SecZeroInit
          desc: Initialize the memory with zeros instead of pseudo-random data.
          type: bit
          default: "0"
          local: "false"
          expose: "true"
          name_top: SecSramCtrlMainZeroInit
        }
      ]
      inter_signal_list:
      [
        {
          name: sram_otp_key
          struct: sram_otp_key
          package: otp_ctrl_pkg
          type: req_rsp
          act: req
          width: 1
          inst_name: sram_ctrl_main
          default: ""
          domain: Main
          top_signame: otp_ctrl_sram_otp_key
          index: 0
        }
        {
          name: ram_cfg
          struct: ram_1p_cfg
          package: prim_ram_1p_pkg
          type: req_rsp
          act: rsp
          width:
          {
            name: NumRamInst
            desc: Number of internal RAM instances. Must be the same as ceil(MemSizeRam / InstSize) .
            param_type: int
            unpacked_dimensions: null
            default: 1
            local: false
            expose: true
            name_top: SramCtrlMainNumRamInst
          }
          inst_name: sram_ctrl_main
          default: ""
          top_signame: sram_ctrl_main_ram_cfg
          index: -1
        }
        {
          name: lc_escalate_en
          struct: lc_tx
          package: lc_ctrl_pkg
          type: uni
          act: rcv
          width: 1
          default: lc_ctrl_pkg::Off
          inst_name: sram_ctrl_main
          domain: Main
          top_signame: lc_ctrl_lc_escalate_en
          index: -1
        }
        {
          name: lc_hw_debug_en
          struct: lc_tx
          package: lc_ctrl_pkg
          type: uni
          act: rcv
          width: 1
          default: lc_ctrl_pkg::Off
          inst_name: sram_ctrl_main
          domain: Main
          top_signame: lc_ctrl_lc_hw_debug_en
          index: -1
        }
        {
          name: otp_en_sram_ifetch
          struct: mubi8
          package: prim_mubi_pkg
          type: uni
          act: rcv
          width: 1
          default: prim_mubi_pkg::MuBi8False
          inst_name: sram_ctrl_main
          top_signame: sram_ctrl_main_otp_en_sram_ifetch
          index: -1
        }
        {
          name: racl_policies
          desc:
            '''
            Incoming RACL policy vector from a racl_ctrl instance.
            The policy selection vector (parameter) selects the policy for each register.
            '''
          struct: racl_policy_vec
          package: top_racl_pkg
          type: uni
          act: rcv
          width: 1
          inst_name: sram_ctrl_main
          index: -1
        }
        {
          name: racl_error
          desc: RACL error log information of this module.
          struct: racl_error_log
          package: top_racl_pkg
          type: uni
          act: req
          width: 1
          inst_name: sram_ctrl_main
          index: -1
        }
        {
          name: sram_rerror
          desc: SRAM read error indicating correctable and uncorrectable ECC errors.
          struct: sram_error_t
          package: sram_ctrl_pkg
          type: uni
          act: req
          width: 1
          inst_name: sram_ctrl_main
          index: -1
        }
        {
          name: regs_tl
          struct: tl
          package: tlul_pkg
          type: req_rsp
          act: rsp
          width: 1
          inst_name: sram_ctrl_main
          default: ""
          end_idx: -1
          top_type: one-to-one
          top_signame: sram_ctrl_main_regs_tl
          index: -1
        }
        {
          name: ram_tl
          struct: tl
          package: tlul_pkg
          type: req_rsp
          act: rsp
          width: 1
          inst_name: sram_ctrl_main
          default: ""
          end_idx: -1
          top_type: one-to-one
          top_signame: sram_ctrl_main_ram_tl
          index: -1
        }
      ]
      generate_dif: true
    }
    {
      name: sram_ctrl_sec
      type: sram_ctrl
      clock_srcs:
      {
        clk_i: main
        clk_otp_i: io_div4
      }
      clock_group: infra
      reset_connections:
      {
        rst_ni:
        {
          name: lc
          domain: Main
        }
        rst_otp_ni:
        {
          name: lc_io_div4
          domain: Main
        }
      }
      param_decl:
      {
        InstrExec: "1"
        NumPrinceRoundsHalf: "2"
        InstSize: "65536"
      }
      base_addrs:
      {
        regs:
        {
          hart: 0x411D0000
        }
        ram:
        {
          hart: 0x10020000
        }
      }
      memory:
      {
        ram:
        {
          label: ram_secondary
          swaccess: rw
          data_intg_passthru: "true"
          exec: True
          byte_write: True
          size: 0x10000
        }
      }
      domain: Main
      clock_connections:
      {
        clk_i: clkmgr_clocks_i.clk_main_infra
        clk_otp_i: clkmgr_clocks_i.clk_io_div4_infra
      }
      param_list:
      [
        {
          name: MemSizeRam
          desc:
            '''
            Memory size of the RAM (in bytes).
            If address scrambling is enabled, this must be a power of 2 or a multiple of 16 KiB.
            For details, check the SRAM scrambling primitive (prim_ram_1p_scr).
            '''
          type: int
          name_top: MemSizeSramCtrlSecRam
          default: 65536
        }
        {
          name: InstSize
          desc: Memory size of a single RAM tile (in bytes).
          type: int
          default: "65536"
          local: "false"
          expose: "true"
          name_top: SramCtrlSecInstSize
        }
        {
          name: NumRamInst
          desc: Number of internal RAM instances. Must be the same as ceil(MemSizeRam / InstSize) .
          type: int
          default: 1
          local: "false"
          expose: "true"
          name_top: SramCtrlSecNumRamInst
        }
        {
          name: InstrExec
          desc: Support execution from SRAM
          type: bit
          default: "1"
          local: "false"
          expose: "true"
          name_top: SramCtrlSecInstrExec
        }
        {
          name: NumPrinceRoundsHalf
          desc: Number of PRINCE half rounds for the SRAM scrambling feature
          type: int
          default: "2"
          local: "false"
          expose: "true"
          name_top: SramCtrlSecNumPrinceRoundsHalf
        }
        {
          name: NumAddrScrRounds
          desc: Number of address scrambling rounds. 0 disables address scrambling.
          type: int
          default: "2"
          local: "false"
          expose: "true"
          name_top: SramCtrlSecNumAddrScrRounds
        }
        {
          name: Outstanding
          desc: Number of outstanding TLUL transactions
          type: int
          default: "2"
          local: "true"
          expose: "true"
          name_top: SramCtrlSecOutstanding
        }
        {
          name: EccCorrection
          desc: Enable single-bit error correction and error logging
          type: bit
          default: "0"
          local: "false"
          expose: "true"
          name_top: SramCtrlSecEccCorrection
        }
        {
          name: SecZeroInit
          desc: Initialize the memory with zeros instead of pseudo-random data.
          type: bit
          default: "0"
          local: "false"
          expose: "true"
          name_top: SecSramCtrlSecZeroInit
        }
      ]
      inter_signal_list:
      [
        {
          name: sram_otp_key
          struct: sram_otp_key
          package: otp_ctrl_pkg
          type: req_rsp
          act: req
          width: 1
          inst_name: sram_ctrl_sec
          default: ""
          domain: Main
          top_signame: otp_ctrl_sram_otp_key
          index: 1
        }
        {
          name: ram_cfg
          struct: ram_1p_cfg
          package: prim_ram_1p_pkg
          type: req_rsp
          act: rsp
          width:
          {
            name: NumRamInst
            desc: Number of internal RAM instances. Must be the same as ceil(MemSizeRam / InstSize) .
            param_type: int
            unpacked_dimensions: null
            default: 1
            local: false
            expose: true
            name_top: SramCtrlSecNumRamInst
          }
          inst_name: sram_ctrl_sec
          default: ""
          top_signame: sram_ctrl_sec_ram_cfg
          index: -1
        }
        {
          name: lc_escalate_en
          struct: lc_tx
          package: lc_ctrl_pkg
          type: uni
          act: rcv
          width: 1
          default: lc_ctrl_pkg::Off
          inst_name: sram_ctrl_sec
          domain: Main
          top_signame: lc_ctrl_lc_escalate_en
          index: -1
        }
        {
          name: lc_hw_debug_en
          struct: lc_tx
          package: lc_ctrl_pkg
          type: uni
          act: rcv
          width: 1
          default: lc_ctrl_pkg::Off
          inst_name: sram_ctrl_sec
          domain: Main
          top_signame: lc_ctrl_lc_hw_debug_en
          index: -1
        }
        {
          name: otp_en_sram_ifetch
          struct: mubi8
          package: prim_mubi_pkg
          type: uni
          act: rcv
          width: 1
          default: prim_mubi_pkg::MuBi8False
          inst_name: sram_ctrl_sec
          top_signame: sram_ctrl_sec_otp_en_sram_ifetch
          index: -1
        }
        {
          name: racl_policies
          desc:
            '''
            Incoming RACL policy vector from a racl_ctrl instance.
            The policy selection vector (parameter) selects the policy for each register.
            '''
          struct: racl_policy_vec
          package: top_racl_pkg
          type: uni
          act: rcv
          width: 1
          inst_name: sram_ctrl_sec
          index: -1
        }
        {
          name: racl_error
          desc: RACL error log information of this module.
          struct: racl_error_log
          package: top_racl_pkg
          type: uni
          act: req
          width: 1
          inst_name: sram_ctrl_sec
          index: -1
        }
        {
          name: sram_rerror
          desc: SRAM read error indicating correctable and uncorrectable ECC errors.
          struct: sram_error_t
          package: sram_ctrl_pkg
          type: uni
          act: req
          width: 1
          inst_name: sram_ctrl_sec
          index: -1
        }
        {
          name: regs_tl
          struct: tl
          package: tlul_pkg
          type: req_rsp
          act: rsp
          width: 1
          inst_name: sram_ctrl_sec
          default: ""
          end_idx: -1
          top_type: one-to-one
          top_signame: sram_ctrl_sec_regs_tl
          index: -1
        }
        {
          name: ram_tl
          struct: tl
          package: tlul_pkg
          type: req_rsp
          act: rsp
          width: 1
          inst_name: sram_ctrl_sec
          default: ""
          end_idx: -1
          top_type: one-to-one
          top_signame: sram_ctrl_sec_ram_tl
          index: -1
        }
      ]
      generate_dif: true
    }
    {
      name: rom_ctrl
      type: rom_ctrl
      clock_srcs:
      {
        clk_i: main
      }
      clock_group: infra
      reset_connections:
      {
        rst_ni:
        {
          name: lc
          domain: Main
        }
      }
      base_addrs:
      {
        rom:
        {
          hart: 0x00040000
        }
        regs:
        {
          hart: 0x411e0000
        }
      }
      memory:
      {
        rom:
        {
          label: rom
          swaccess: ro
          data_intg_passthru: True
          exec: True
          byte_write: False
          size: 0x30000
        }
      }
      param_decl:
      {
        SecDisableScrambling: 1'b0
      }
      domain: Main
      clock_connections:
      {
        clk_i: clkmgr_clocks_i.clk_main_infra
      }
      param_list:
      [
        {
          name: BootRomInitFile
          desc: Contents of ROM
          type: ""
          default: '''""'''
          local: "false"
          expose: "true"
          name_top: RomCtrlBootRomInitFile
        }
        {
          name: FlopToKmac
          desc:
            '''
            Add a flop stage between the output of the ROM and the data that gets
            sent to KMAC. This may break long paths in a target chip, at the cost of
            adding chip area.
            '''
          type: bit
          default: 1'b0
          local: "true"
          expose: "true"
          name_top: RomCtrlFlopToKmac
        }
        {
          name: SecDisableScrambling
          desc:
            '''
            Disable scrambling and checking in rom_ctrl, turning the block into a
            simple ROM wrapper. This isn't intended for real chips, but is useful
            for small FPGA targets where there's not space for the PRINCE
            primitives.
            '''
          type: bit
          default: 1'b0
          local: "false"
          expose: "true"
          name_top: SecRomCtrlDisableScrambling
        }
        {
          name: MemSizeRom
          desc: Memory size of the ROM (in bytes).
          type: int
          name_top: MemSizeRomCtrlRom
          default: 196608
        }
      ]
      inter_signal_list:
      [
        {
          name: rom_cfg
          struct: rom_cfg
          package: prim_rom_pkg
          type: req_rsp
          act: rsp
          width: 1
          inst_name: rom_ctrl
          default: ""
          top_signame: rom_ctrl_rom_cfg
          index: -1
        }
        {
          name: pwrmgr_data
          struct: pwrmgr_data
          package: rom_ctrl_pkg
          type: uni
          act: req
          width: 1
          inst_name: rom_ctrl
          default: ""
          end_idx: -1
          top_type: broadcast
          top_signame: rom_ctrl_pwrmgr_data
          index: -1
          external: true
          conn_type: false
        }
        {
          name: keymgr_data
          struct: keymgr_data
          package: rom_ctrl_pkg
          type: uni
          act: req
          width: 1
          inst_name: rom_ctrl
          default: ""
          end_idx: -1
          top_type: broadcast
          top_signame: rom_ctrl_keymgr_data
          index: -1
        }
        {
          name: kmac_data
          struct: app
          package: kmac_pkg
          type: req_rsp
          act: req
          width: 1
          inst_name: rom_ctrl
          default: ""
          domain: Main
          top_signame: kmac_app
          index: 2
        }
        {
          name: regs_tl
          struct: tl
          package: tlul_pkg
          type: req_rsp
          act: rsp
          width: 1
          inst_name: rom_ctrl
          default: ""
          end_idx: -1
          top_type: one-to-one
          top_signame: rom_ctrl_regs_tl
          index: -1
        }
        {
          name: rom_tl
          struct: tl
          package: tlul_pkg
          type: req_rsp
          act: rsp
          width: 1
          inst_name: rom_ctrl
          default: ""
          end_idx: -1
          top_type: one-to-one
          top_signame: rom_ctrl_rom_tl
          index: -1
        }
      ]
      generate_dif: true
    }
    {
      name: rv_core_ibex
      type: rv_core_ibex
      template_type: rv_core_ibex
      attr: ipgen
      ipgen_params:
      {
        num_regions: 2
        cheriot_available: true
      }
      param_decl:
      {
        PMPEnable: "1"
        PMPGranularity: "0"
        PMPNumRegions: "16"
        MHPMCounterNum: "2"
        MHPMCounterWidth: "32"
        PMPRstCfg: ibex_pmp_reset_pkg::PmpCfgRst
        PMPRstAddr: ibex_pmp_reset_pkg::PmpAddrRst
        PMPRstMsecCfg: ibex_pmp_reset_pkg::PmpMseccfgRst
        CheriotRevBitmapAddrWidth: $clog2(tl_main_pkg::ADDR_SIZE_CHERIOT_MEM_SYS__REVBM)
        CheriotRevBitmapBaseAddr: tl_main_pkg::ADDR_SPACE_CHERIOT_MEM_SYS__REVBM
        CheriotTrvkHeapBaseAddr: tl_main_pkg::ADDR_SPACE_SRAM_CTRL_MAIN__RAM
        RV32E: "0"
        RV32M: ibex_pkg::RV32MSingleCycle
        RV32B: ibex_pkg::RV32BFull
        RV32ZC: ibex_pkg::RV32ZcaZcbZcmp
        RegFile: ibex_pkg::RegFileFF
        BranchTargetALU: "1"
        WritebackStage: "1"
        ICache: "1"
        ICacheECC: "1"
        ICacheScramble: "1"
        BranchPredictor: "0"
        DbgTriggerEn: "1"
        DbgHwBreakNum: "4"
        SecureIbex: "1"
        DmBaseAddr: tl_main_pkg::ADDR_SPACE_RV_DM__MEM
        DmAddrMask: tl_main_pkg::ADDR_MASK_RV_DM__MEM
        DmHaltAddr: tl_main_pkg::ADDR_SPACE_RV_DM__MEM + dm::HaltAddress[31:0]
        DmExceptionAddr: tl_main_pkg::ADDR_SPACE_RV_DM__MEM + dm::ExceptionAddress[31:0]
        PipeLine: "0"
        NEscalationSeverities: AlertHandlerEscNumSeverities
        WidthPingCounter: AlertHandlerEscPingCountWidth
      }
      clock_srcs:
      {
        clk_i: main
        clk_edn_i: main
        clk_esc_i:
        {
          clock: io_div4
          group: secure
        }
        clk_otp_i:
        {
          clock: io_div4
          group: secure
        }
      }
      clock_group: infra
      reset_connections:
      {
        rst_ni:
        {
          name: lc
          domain: Main
        }
        rst_edn_ni:
        {
          name: lc
          domain: Main
        }
        rst_esc_ni:
        {
          name: lc_io_div4
          domain: Main
        }
        rst_otp_ni:
        {
          name: lc_io_div4
          domain: Main
        }
      }
      domain: Main
      clock_connections:
      {
        clk_i: clkmgr_clocks_i.clk_main_infra
        clk_edn_i: clkmgr_clocks_i.clk_main_infra
        clk_esc_i: clkmgr_clocks_i.clk_io_div4_secure
        clk_otp_i: clkmgr_clocks_i.clk_io_div4_secure
      }
      memory: {}
      param_list:
      [
        {
          name: NEscalationSeverities
          desc: Number of escalation severities
          type: int unsigned
          default: AlertHandlerEscNumSeverities
          local: "false"
          expose: "false"
          name_top: RvCoreIbexNEscalationSeverities
        }
        {
          name: WidthPingCounter
          desc: Width of the ping counter
          type: int unsigned
          default: AlertHandlerEscPingCountWidth
          local: "false"
          expose: "false"
          name_top: RvCoreIbexWidthPingCounter
        }
        {
          name: PMPEnable
          desc: Enable PMP
          type: bit
          default: "1"
          local: "false"
          expose: "true"
          name_top: RvCoreIbexPMPEnable
        }
        {
          name: PMPGranularity
          desc: PMP Granularity
          type: int unsigned
          default: "0"
          local: "false"
          expose: "true"
          name_top: RvCoreIbexPMPGranularity
        }
        {
          name: PMPNumRegions
          desc: PMP number of regions
          type: int unsigned
          default: "16"
          local: "false"
          expose: "true"
          name_top: RvCoreIbexPMPNumRegions
        }
        {
          name: MHPMCounterNum
          desc: "Number of the MHPM counter "
          type: int unsigned
          default: "2"
          local: "false"
          expose: "true"
          name_top: RvCoreIbexMHPMCounterNum
        }
        {
          name: MHPMCounterWidth
          desc: "Width of the MHPM Counter "
          type: int unsigned
          default: "32"
          local: "false"
          expose: "true"
          name_top: RvCoreIbexMHPMCounterWidth
        }
        {
          name: PMPRstCfg
          desc: Reset value of PMP config CSRs
          type: ibex_pkg::pmp_cfg_t
          unpacked_dimensions: "[16]"
          default: ibex_pmp_reset_pkg::PmpCfgRst
          local: "false"
          expose: "true"
          name_top: RvCoreIbexPMPRstCfg
        }
        {
          name: PMPRstAddr
          desc: Reset value of PMP address CSRs
          type: logic [33:0]
          unpacked_dimensions: "[16]"
          default: ibex_pmp_reset_pkg::PmpAddrRst
          local: "false"
          expose: "true"
          name_top: RvCoreIbexPMPRstAddr
        }
        {
          name: PMPRstMsecCfg
          desc: Reset value of MSECCFG CSR
          type: ibex_pkg::pmp_mseccfg_t
          default: ibex_pmp_reset_pkg::PmpMseccfgRst
          local: "false"
          expose: "true"
          name_top: RvCoreIbexPMPRstMsecCfg
        }
        {
          name: CheriotRevBitmapAddrWidth
          desc: Address width of the TRVK revocation bitmap.
          type: int unsigned
          default: $clog2(tl_main_pkg::ADDR_SIZE_CHERIOT_MEM_SYS__REVBM)
          local: "false"
          expose: "true"
          name_top: RvCoreIbexCheriotRevBitmapAddrWidth
        }
        {
          name: CheriotRevBitmapBaseAddr
          desc: Base address of the TRVK revocation bitmap.
          type: int unsigned
          default: tl_main_pkg::ADDR_SPACE_CHERIOT_MEM_SYS__REVBM
          local: "false"
          expose: "true"
          name_top: RvCoreIbexCheriotRevBitmapBaseAddr
        }
        {
          name: CheriotTrvkHeapBaseAddr
          desc: Base address of the heap.
          type: int unsigned
          default: tl_main_pkg::ADDR_SPACE_SRAM_CTRL_MAIN__RAM
          local: "false"
          expose: "true"
          name_top: RvCoreIbexCheriotTrvkHeapBaseAddr
        }
        {
          name: RV32E
          desc: RV32E
          type: bit
          default: "0"
          local: "false"
          expose: "true"
          name_top: RvCoreIbexRV32E
        }
        {
          name: RV32M
          desc: RV32M
          type: ibex_pkg::rv32m_e
          default: ibex_pkg::RV32MSingleCycle
          local: "false"
          expose: "true"
          name_top: RvCoreIbexRV32M
        }
        {
          name: RV32B
          desc: RV32B
          type: ibex_pkg::rv32b_e
          default: ibex_pkg::RV32BFull
          local: "false"
          expose: "true"
          name_top: RvCoreIbexRV32B
        }
        {
          name: RV32ZC
          desc: RV32ZC
          type: ibex_pkg::rv32zc_e
          default: ibex_pkg::RV32ZcaZcbZcmp
          local: "false"
          expose: "true"
          name_top: RvCoreIbexRV32ZC
        }
        {
          name: RegFile
          desc: Reg file
          type: ibex_pkg::regfile_e
          default: ibex_pkg::RegFileFF
          local: "false"
          expose: "true"
          name_top: RvCoreIbexRegFile
        }
        {
          name: BranchTargetALU
          desc: Branch target ALU
          type: bit
          default: "1"
          local: "false"
          expose: "true"
          name_top: RvCoreIbexBranchTargetALU
        }
        {
          name: WritebackStage
          desc: Write back stage
          type: bit
          default: "1"
          local: "false"
          expose: "true"
          name_top: RvCoreIbexWritebackStage
        }
        {
          name: ICache
          desc: Instruction cache
          type: bit
          default: "1"
          local: "false"
          expose: "true"
          name_top: RvCoreIbexICache
        }
        {
          name: ICacheECC
          desc: Instruction cache ECC
          type: bit
          default: "1"
          local: "false"
          expose: "true"
          name_top: RvCoreIbexICacheECC
        }
        {
          name: ICacheScramble
          desc: Scramble instruction cach
          type: bit
          default: "1"
          local: "false"
          expose: "true"
          name_top: RvCoreIbexICacheScramble
        }
        {
          name: ICacheNWays
          desc: Number of instruction cache ways
          type: int unsigned
          default: 2
          local: "false"
          expose: "true"
          name_top: RvCoreIbexICacheNWays
        }
        {
          name: BranchPredictor
          desc: Branch predictor
          type: bit
          default: "0"
          local: "false"
          expose: "true"
          name_top: RvCoreIbexBranchPredictor
        }
        {
          name: DbgTriggerEn
          desc: Enable degug trigger
          type: bit
          default: "1"
          local: "false"
          expose: "true"
          name_top: RvCoreIbexDbgTriggerEn
        }
        {
          name: DbgHwBreakNum
          desc: Number of debug hardware break
          type: int
          default: "4"
          local: "false"
          expose: "true"
          name_top: RvCoreIbexDbgHwBreakNum
        }
        {
          name: SecureIbex
          desc: "Width of the MHPM Counter "
          type: bit
          default: "1"
          local: "false"
          expose: "true"
          name_top: RvCoreIbexSecureIbex
        }
        {
          name: DmBaseAddr
          desc: Base address of Debug Module
          type: int unsigned
          default: tl_main_pkg::ADDR_SPACE_RV_DM__MEM
          local: "false"
          expose: "true"
          name_top: RvCoreIbexDmBaseAddr
        }
        {
          name: DmAddrMask
          desc: Adress mask of Debug Module
          type: int unsigned
          default: tl_main_pkg::ADDR_MASK_RV_DM__MEM
          local: "false"
          expose: "true"
          name_top: RvCoreIbexDmAddrMask
        }
        {
          name: DmHaltAddr
          desc: Halt address
          type: int unsigned
          default: tl_main_pkg::ADDR_SPACE_RV_DM__MEM + dm::HaltAddress[31:0]
          local: "false"
          expose: "true"
          name_top: RvCoreIbexDmHaltAddr
        }
        {
          name: DmExceptionAddr
          desc: Exception address
          type: int unsigned
          default: tl_main_pkg::ADDR_SPACE_RV_DM__MEM + dm::ExceptionAddress[31:0]
          local: "false"
          expose: "true"
          name_top: RvCoreIbexDmExceptionAddr
        }
        {
          name: PipeLine
          desc: Pipe line
          type: bit
          default: "0"
          local: "false"
          expose: "true"
          name_top: RvCoreIbexPipeLine
        }
        {
          name: TlulHostUserRsvdBits
          desc: TLUL user bits sent on outgoing transfers.
          type: logic [tlul_pkg::RsvdWidth-1:0]
          default: "'0"
          local: "false"
          expose: "true"
          name_top: RvCoreIbexTlulHostUserRsvdBits
        }
        {
          name: CsrMvendorId
          desc:
            '''
            mvendorid: encoding of manufacturer/provider
            0 indicates this field is not implemented.
            Ibex implementors may wish to set their own JEDEC ID here.
            '''
          type: logic [31:0]
          default: "'0"
          local: "false"
          expose: "true"
          name_top: RvCoreIbexCsrMvendorId
        }
        {
          name: CsrMimpId
          desc:
            '''
            mimpid: encoding of processor implementation version
            0 indicates this field is not implemented.
            Ibex implementors may wish to indicate an RTL/netlist version here using their own unique encoding (e.g. 32 bits of the git hash of the implemented commit).
            '''
          type: logic [31:0]
          default: "'0"
          local: "false"
          expose: "true"
          name_top: RvCoreIbexCsrMimpId
        }
        {
          name: InstructionPipeline
          desc: Add a pipeline stage in the instruction interface between Ibex and the address translation
          type: bit
          default: 1'b0
          local: "true"
          expose: "true"
          name_top: RvCoreIbexInstructionPipeline
        }
      ]
      inter_signal_list:
      [
        {
          name: rst_cpu_n
          struct: logic
          type: uni
          act: req
          width: 1
          inst_name: rv_core_ibex
          index: -1
        }
        {
          name: cheriot_ena
          desc: CHERIoT mode enable.
          struct: mubi4
          package: prim_mubi_pkg
          type: uni
          act: req
          width: 1
          default: prim_mubi_pkg::MuBi4False
          inst_name: rv_core_ibex
          end_idx: -1
          top_type: broadcast
          top_signame: rv_core_ibex_cheriot_ena
          index: -1
        }
        {
          name: cored_tl_h
          desc: Core data host port to the CHERIoT memory subsystem.
          struct: tl
          package: tlul_pkg
          type: req_rsp
          act: req
          width: 1
          inst_name: rv_core_ibex
          default: ""
          end_idx: -1
          top_type: one-to-one
          top_signame: rv_core_ibex_cored_tl_h
          index: -1
        }
        {
          name: cored_tag_h2d
          desc: CHERIoT capability tag carried with the A-channel of cored_tl_h.
          struct: logic
          type: uni
          act: req
          width: 1
          default: 1'b0
          inst_name: rv_core_ibex
          package: ""
          end_idx: -1
          top_type: broadcast
          top_signame: rv_core_ibex_cored_tag_h2d
          index: -1
        }
        {
          name: cored_tag_d2h
          desc: Capability tag returned on the D-channel of cored_tl_h.
          struct: logic
          type: uni
          act: rcv
          width: 1
          default: 1'b0
          inst_name: rv_core_ibex
          package: ""
          domain: Main
          top_signame: cheriot_mem_sys_cored_tag_d2h
          index: -1
        }
        {
          name: corerevbm_tl
          desc: Core revocation bitmap host port.
          struct: tl
          package: tlul_pkg
          type: req_rsp
          act: req
          width: 1
          inst_name: rv_core_ibex
          default: ""
          end_idx: -1
          top_type: one-to-one
          top_signame: rv_core_ibex_corerevbm_tl
          index: -1
        }
        {
          name: ram_cfg_icache_tag
          struct: ram_1p_cfg
          package: prim_ram_1p_pkg
          type: req_rsp
          act: rsp
          width:
          {
            name: ICacheNWays
            desc: Number of instruction cache ways
            param_type: int unsigned
            unpacked_dimensions: null
            default: 2
            local: false
            expose: true
            name_top: RvCoreIbexICacheNWays
          }
          inst_name: rv_core_ibex
          default: ""
          top_signame: rv_core_ibex_ram_cfg_icache_tag
          index: -1
        }
        {
          name: ram_cfg_icache_data
          struct: ram_1p_cfg
          package: prim_ram_1p_pkg
          type: req_rsp
          act: rsp
          width:
          {
            name: ICacheNWays
            desc: Number of instruction cache ways
            param_type: int unsigned
            unpacked_dimensions: null
            default: 2
            local: false
            expose: true
            name_top: RvCoreIbexICacheNWays
          }
          inst_name: rv_core_ibex
          default: ""
          top_signame: rv_core_ibex_ram_cfg_icache_data
          index: -1
        }
        {
          name: hart_id
          struct: logic
          type: uni
          act: rcv
          width: 32
          inst_name: rv_core_ibex
          default: ""
          package: ""
          top_signame: rv_core_ibex_hart_id
          index: -1
        }
        {
          name: boot_addr
          struct: logic
          type: uni
          act: rcv
          width: 32
          inst_name: rv_core_ibex
          default: ""
          package: ""
          top_signame: rv_core_ibex_boot_addr
          index: -1
        }
        {
          name: irq_software
          struct: logic
          type: uni
          act: rcv
          width: 1
          inst_name: rv_core_ibex
          default: ""
          package: ""
          domain: Main
          top_signame: rv_plic_msip
          index: -1
        }
        {
          name: irq_timer
          struct: logic
          type: uni
          act: rcv
          width: 1
          inst_name: rv_core_ibex
          default: ""
          package: ""
          top_signame: rv_core_ibex_irq_timer
          index: -1
        }
        {
          name: irq_external
          struct: logic
          type: uni
          act: rcv
          width: 1
          inst_name: rv_core_ibex
          default: ""
          package: ""
          domain: Main
          top_signame: rv_plic_irq
          index: -1
        }
        {
          name: esc_tx
          struct: esc_tx
          package: prim_esc_pkg
          type: uni
          act: rcv
          width: 1
          inst_name: rv_core_ibex
          default: ""
          domain: Main
          top_signame: alert_handler_esc_tx
          index: 0
        }
        {
          name: esc_rx
          struct: esc_rx
          package: prim_esc_pkg
          type: uni
          act: req
          width: 1
          inst_name: rv_core_ibex
          default: ""
          domain: Main
          top_signame: alert_handler_esc_rx
          index: 0
        }
        {
          name: debug_req
          struct: logic
          type: uni
          act: rcv
          width: 1
          inst_name: rv_core_ibex
          default: ""
          package: ""
          domain: Main
          top_signame: rv_dm_debug_req
          index: -1
        }
        {
          name: crash_dump
          struct: cpu_crash_dump
          package: rv_core_ibex_pkg
          type: uni
          act: req
          width: 1
          inst_name: rv_core_ibex
          default: ""
          end_idx: -1
          top_type: broadcast
          top_signame: rv_core_ibex_crash_dump
          index: -1
          external: true
          conn_type: false
        }
        {
          name: lc_cpu_en
          struct: lc_tx
          package: lc_ctrl_pkg
          type: uni
          act: rcv
          width: 1
          default: lc_ctrl_pkg::On
          inst_name: rv_core_ibex
          domain: Main
          top_signame: lc_ctrl_lc_cpu_en
          index: -1
        }
        {
          name: pwrmgr_cpu_en
          struct: lc_tx
          package: lc_ctrl_pkg
          type: uni
          act: rcv
          width: 1
          inst_name: rv_core_ibex
          default: ""
          domain: Main
          top_signame: pwrmgr_fetch_en
          index: -1
          external: true
          conn_type: false
        }
        {
          name: pwrmgr
          struct: cpu_pwrmgr
          package: rv_core_ibex_pkg
          type: uni
          act: req
          width: 1
          inst_name: rv_core_ibex
          default: ""
          end_idx: -1
          top_type: broadcast
          top_signame: rv_core_ibex_pwrmgr
          index: -1
          external: true
          conn_type: false
        }
        {
          name: nmi_wdog
          struct: logic
          type: uni
          act: rcv
          width: 1
          inst_name: rv_core_ibex
          default: ""
          package: ""
          domain: Main
          top_signame: aon_timer_nmi_wdog_timer_bark
          index: -1
          external: true
          conn_type: false
        }
        {
          name: edn
          struct: edn
          package: edn_pkg
          type: req_rsp
          act: req
          width: 1
          inst_name: rv_core_ibex
          default: ""
          domain: Main
          top_signame: edn0_edn
          index: 7
        }
        {
          name: icache_otp_key
          struct: sram_otp_key
          package: otp_ctrl_pkg
          type: req_rsp
          act: req
          width: 1
          inst_name: rv_core_ibex
          default: ""
          domain: Main
          top_signame: otp_ctrl_sram_otp_key
          index: 4
        }
        {
          name: corei_tl_h
          struct: tl
          package: tlul_pkg
          type: req_rsp
          act: req
          width: 1
          inst_name: rv_core_ibex
          default: ""
          domain: Main
          top_signame: main_tl_rv_core_ibex__corei
          index: -1
        }
        {
          name: cfg_tl_d
          struct: tl
          package: tlul_pkg
          type: req_rsp
          act: rsp
          width: 1
          inst_name: rv_core_ibex
          default: ""
          end_idx: -1
          top_type: one-to-one
          top_signame: rv_core_ibex_cfg_tl_d
          index: -1
        }
      ]
      base_addrs:
      {
        cfg:
        {
          hart: 0x411F0000
        }
      }
      generate_dif: true
    }
    {
      name: cheriot_mem_sys
      type: cheriot_mem_sys
      clock_srcs:
      {
        clk_i: main
      }
      clock_group: infra
      reset_connections:
      {
        rst_ni:
        {
          name: lc
          domain: Main
        }
      }
      param_decl:
      {
        MainSramBaseAddr: tl_main_pkg::ADDR_SPACE_SRAM_CTRL_MAIN__RAM
        MainSramTopAddr: tl_main_pkg::ADDR_SPACE_SRAM_CTRL_SEC__RAM + tl_main_pkg::ADDR_MASK_SRAM_CTRL_SEC__RAM + 1
        NvmBaseAddr: tl_main_pkg::ADDR_SPACE_RRAM_CTRL__HOST
        NvmTopAddr: tl_main_pkg::ADDR_SPACE_RRAM_CTRL__HOST + tl_main_pkg::ADDR_MASK_RRAM_CTRL__HOST + 1
        MetaSramBaseAddr: tl_main_pkg::ADDR_SPACE_CHERIOT_MEM_SYS__REVBM
      }
      base_addrs:
      {
        regs:
        {
          hart: 0x411B0000
        }
        revbm:
        {
          hart: 0x11000000
        }
      }
      memory:
      {
        revbm:
        {
          label: cheriot_revbm
          swaccess: rw
          data_intg_passthru: True
          exec: false
          byte_write: False
          size: 0xc00
        }
      }
      domain: Main
      clock_connections:
      {
        clk_i: clkmgr_clocks_i.clk_main_infra
      }
      param_list:
      [
        {
          name: MainSramBaseAddr
          desc: Base address of the main SRAM region (inclusive).
          type: logic [top_pkg::TL_AW-1:0]
          default: tl_main_pkg::ADDR_SPACE_SRAM_CTRL_MAIN__RAM
          local: "false"
          expose: "true"
          name_top: CheriotMemSysMainSramBaseAddr
        }
        {
          name: MainSramTopAddr
          desc: Top address of the main SRAM region (exclusive).
          type: logic [top_pkg::TL_AW-1:0]
          default: tl_main_pkg::ADDR_SPACE_SRAM_CTRL_SEC__RAM + tl_main_pkg::ADDR_MASK_SRAM_CTRL_SEC__RAM + 1
          local: "false"
          expose: "true"
          name_top: CheriotMemSysMainSramTopAddr
        }
        {
          name: NvmBaseAddr
          desc: Base address of the NVM region (inclusive).
          type: logic [top_pkg::TL_AW-1:0]
          default: tl_main_pkg::ADDR_SPACE_RRAM_CTRL__HOST
          local: "false"
          expose: "true"
          name_top: CheriotMemSysNvmBaseAddr
        }
        {
          name: NvmTopAddr
          desc: Top address of the NVM region (exclusive).
          type: logic [top_pkg::TL_AW-1:0]
          default: tl_main_pkg::ADDR_SPACE_RRAM_CTRL__HOST + tl_main_pkg::ADDR_MASK_RRAM_CTRL__HOST + 1
          local: "false"
          expose: "true"
          name_top: CheriotMemSysNvmTopAddr
        }
        {
          name: MetaSramBaseAddr
          desc: Base address of the CHERIoT meta SRAM region.
          type: logic [top_pkg::TL_AW-1:0]
          default: tl_main_pkg::ADDR_SPACE_CHERIOT_MEM_SYS__REVBM
          local: "false"
          expose: "true"
          name_top: CheriotMemSysMetaSramBaseAddr
        }
        {
          name: MemSizeRevbm
          desc:
            '''
            Size of the revocation bitmap window (in bytes).
            Must match the size derived from the main SRAM region; this is checked by an
            assertion in the RTL.
            '''
          type: int
          name_top: MemSizeCheriotMemSysRevbm
          default: 3072
        }
      ]
      inter_signal_list:
      [
        {
          name: cheriot_ena
          desc: CHERIoT mode enable.
          struct: mubi4
          package: prim_mubi_pkg
          type: uni
          act: rcv
          width: 1
          default: prim_mubi_pkg::MuBi4False
          inst_name: cheriot_mem_sys
          domain: Main
          top_signame: rv_core_ibex_cheriot_ena
          index: -1
        }
        {
          name: cored_tl_d
          desc: Data port from the core.
          struct: tl
          package: tlul_pkg
          type: req_rsp
          act: rsp
          width: 1
          inst_name: cheriot_mem_sys
          default: ""
          domain: Main
          top_signame: rv_core_ibex_cored_tl_h
          index: -1
        }
        {
          name: cored_tag_h2d
          desc: CHERIoT capability tag carried with the A-channel of cored_tl_h.
          struct: logic
          type: uni
          act: rcv
          width: 1
          default: 1'b0
          inst_name: cheriot_mem_sys
          package: ""
          domain: Main
          top_signame: rv_core_ibex_cored_tag_h2d
          index: -1
        }
        {
          name: cored_tag_d2h
          desc: Capability tag returned on the D-channel of cored_tl_h.
          struct: logic
          type: uni
          act: req
          width: 1
          default: 1'b0
          inst_name: cheriot_mem_sys
          package: ""
          end_idx: -1
          top_type: broadcast
          top_signame: cheriot_mem_sys_cored_tag_d2h
          index: -1
        }
        {
          name: corerevbm_tl
          desc: TRVK (tag revocation) revocation bitmap port from the core.
          struct: tl
          package: tlul_pkg
          type: req_rsp
          act: rsp
          width: 1
          inst_name: cheriot_mem_sys
          default: ""
          domain: Main
          top_signame: rv_core_ibex_corerevbm_tl
          index: -1
        }
        {
          name: meta_sram_tl
          desc: Host TL-UL port to the external meta SRAM controller's RAM interface.
          struct: tl
          package: tlul_pkg
          type: req_rsp
          act: req
          width: 1
          inst_name: cheriot_mem_sys
          default: ""
          end_idx: -1
          top_type: one-to-one
          top_signame: cheriot_mem_sys_meta_sram_tl
          index: -1
        }
        {
          name: cored_tl_h
          struct: tl
          package: tlul_pkg
          type: req_rsp
          act: req
          width: 1
          inst_name: cheriot_mem_sys
          default: ""
          domain: Main
          top_signame: main_tl_cheriot_mem_sys__cored
          index: -1
        }
        {
          name: tbre_tl_h
          struct: tl
          package: tlul_pkg
          type: req_rsp
          act: req
          width: 1
          inst_name: cheriot_mem_sys
          default: ""
          domain: Main
          top_signame: main_tl_cheriot_mem_sys__tbre
          index: -1
        }
        {
          name: regs_tl_d
          struct: tl
          package: tlul_pkg
          type: req_rsp
          act: rsp
          width: 1
          inst_name: cheriot_mem_sys
          default: ""
          end_idx: -1
          top_type: one-to-one
          top_signame: cheriot_mem_sys_regs_tl_d
          index: -1
        }
        {
          name: revbm_tl_d
          struct: tl
          package: tlul_pkg
          type: req_rsp
          act: rsp
          width: 1
          inst_name: cheriot_mem_sys
          default: ""
          end_idx: -1
          top_type: one-to-one
          top_signame: cheriot_mem_sys_revbm_tl_d
          index: -1
        }
      ]
      generate_dif: true
    }
    {
      name: sram_ctrl_meta
      type: sram_ctrl
      clock_srcs:
      {
        clk_i: main
        clk_otp_i: io_div4
      }
      clock_group: infra
      reset_connections:
      {
        rst_ni:
        {
          name: lc
          domain: Main
        }
        rst_otp_ni:
        {
          name: lc_io_div4
          domain: Main
        }
      }
      param_decl:
      {
        InstrExec: "0"
        NumAddrScrRounds: "0"
        NumPrinceRoundsHalf: "2"
        InstSize: "38912"
        SecZeroInit: "1"
      }
      base_addrs:
      {
        regs:
        {
          hart: 0x411A0000
        }
        ram:
        {
          hart: 0x11000000
        }
      }
      memory:
      {
        ram:
        {
          label: ram_cheriot_meta
          swaccess: rw
          data_intg_passthru: "true"
          exec: false
          byte_write: False
          size: 0x9800
        }
      }
      domain: Main
      clock_connections:
      {
        clk_i: clkmgr_clocks_i.clk_main_infra
        clk_otp_i: clkmgr_clocks_i.clk_io_div4_infra
      }
      param_list:
      [
        {
          name: MemSizeRam
          desc:
            '''
            Memory size of the RAM (in bytes).
            If address scrambling is enabled, this must be a power of 2 or a multiple of 16 KiB.
            For details, check the SRAM scrambling primitive (prim_ram_1p_scr).
            '''
          type: int
          name_top: MemSizeSramCtrlMetaRam
          default: 38912
        }
        {
          name: InstSize
          desc: Memory size of a single RAM tile (in bytes).
          type: int
          default: "38912"
          local: "false"
          expose: "true"
          name_top: SramCtrlMetaInstSize
        }
        {
          name: NumRamInst
          desc: Number of internal RAM instances. Must be the same as ceil(MemSizeRam / InstSize) .
          type: int
          default: 1
          local: "false"
          expose: "true"
          name_top: SramCtrlMetaNumRamInst
        }
        {
          name: InstrExec
          desc: Support execution from SRAM
          type: bit
          default: "0"
          local: "false"
          expose: "true"
          name_top: SramCtrlMetaInstrExec
        }
        {
          name: NumPrinceRoundsHalf
          desc: Number of PRINCE half rounds for the SRAM scrambling feature
          type: int
          default: "2"
          local: "false"
          expose: "true"
          name_top: SramCtrlMetaNumPrinceRoundsHalf
        }
        {
          name: NumAddrScrRounds
          desc: Number of address scrambling rounds. 0 disables address scrambling.
          type: int
          default: "0"
          local: "false"
          expose: "true"
          name_top: SramCtrlMetaNumAddrScrRounds
        }
        {
          name: Outstanding
          desc: Number of outstanding TLUL transactions
          type: int
          default: "2"
          local: "true"
          expose: "true"
          name_top: SramCtrlMetaOutstanding
        }
        {
          name: EccCorrection
          desc: Enable single-bit error correction and error logging
          type: bit
          default: "0"
          local: "false"
          expose: "true"
          name_top: SramCtrlMetaEccCorrection
        }
        {
          name: SecZeroInit
          desc: Initialize the memory with zeros instead of pseudo-random data.
          type: bit
          default: "1"
          local: "false"
          expose: "true"
          name_top: SecSramCtrlMetaZeroInit
        }
      ]
      inter_signal_list:
      [
        {
          name: sram_otp_key
          struct: sram_otp_key
          package: otp_ctrl_pkg
          type: req_rsp
          act: req
          width: 1
          inst_name: sram_ctrl_meta
          default: ""
          domain: Main
          top_signame: otp_ctrl_sram_otp_key
          index: 3
        }
        {
          name: ram_cfg
          struct: ram_1p_cfg
          package: prim_ram_1p_pkg
          type: req_rsp
          act: rsp
          width:
          {
            name: NumRamInst
            desc: Number of internal RAM instances. Must be the same as ceil(MemSizeRam / InstSize) .
            param_type: int
            unpacked_dimensions: null
            default: 1
            local: false
            expose: true
            name_top: SramCtrlMetaNumRamInst
          }
          inst_name: sram_ctrl_meta
          default: ""
          top_signame: sram_ctrl_meta_ram_cfg
          index: -1
        }
        {
          name: lc_escalate_en
          struct: lc_tx
          package: lc_ctrl_pkg
          type: uni
          act: rcv
          width: 1
          default: lc_ctrl_pkg::Off
          inst_name: sram_ctrl_meta
          domain: Main
          top_signame: lc_ctrl_lc_escalate_en
          index: -1
        }
        {
          name: lc_hw_debug_en
          struct: lc_tx
          package: lc_ctrl_pkg
          type: uni
          act: rcv
          width: 1
          default: lc_ctrl_pkg::Off
          inst_name: sram_ctrl_meta
          domain: Main
          top_signame: lc_ctrl_lc_hw_debug_en
          index: -1
        }
        {
          name: otp_en_sram_ifetch
          struct: mubi8
          package: prim_mubi_pkg
          type: uni
          act: rcv
          width: 1
          default: prim_mubi_pkg::MuBi8False
          inst_name: sram_ctrl_meta
          index: -1
        }
        {
          name: racl_policies
          desc:
            '''
            Incoming RACL policy vector from a racl_ctrl instance.
            The policy selection vector (parameter) selects the policy for each register.
            '''
          struct: racl_policy_vec
          package: top_racl_pkg
          type: uni
          act: rcv
          width: 1
          inst_name: sram_ctrl_meta
          index: -1
        }
        {
          name: racl_error
          desc: RACL error log information of this module.
          struct: racl_error_log
          package: top_racl_pkg
          type: uni
          act: req
          width: 1
          inst_name: sram_ctrl_meta
          index: -1
        }
        {
          name: sram_rerror
          desc: SRAM read error indicating correctable and uncorrectable ECC errors.
          struct: sram_error_t
          package: sram_ctrl_pkg
          type: uni
          act: req
          width: 1
          inst_name: sram_ctrl_meta
          index: -1
        }
        {
          name: regs_tl
          struct: tl
          package: tlul_pkg
          type: req_rsp
          act: rsp
          width: 1
          inst_name: sram_ctrl_meta
          default: ""
          end_idx: -1
          top_type: one-to-one
          top_signame: sram_ctrl_meta_regs_tl
          index: -1
        }
        {
          name: ram_tl
          struct: tl
          package: tlul_pkg
          type: req_rsp
          act: rsp
          width: 1
          inst_name: sram_ctrl_meta
          default: ""
          domain: Main
          top_signame: cheriot_mem_sys_meta_sram_tl
          index: -1
        }
      ]
      generate_dif: true
    }
  ]
  port: []
  inter_module:
  {
    connect:
    {
      ast.obs_ctrl:
      [
        rram_macro.obs_ctrl
      ]
      ast.adc:
      [
        adc_ctrl.adc
      ]
      ast.sns_clks:
      [
        clkmgr.clocks
      ]
      ast.sns_rsts:
      [
        rstmgr.resets
      ]
      ast.clk_src_sys_jen:
      [
        clkmgr.jitter_en
      ]
      ast.rng_b:
      [
        entropy_src.entropy_src_rng_bits
      ]
      entropy_src.entropy_src_rng_enable:
      [
        ast.rng_en
      ]
      entropy_src.rng_fips:
      [
        ast.rng_fips
      ]
      ast.rng_val:
      [
        entropy_src.entropy_src_rng_valid
      ]
      ast.init_done:
      [
        clkmgr.calib_rdy
        sensor_ctrl.ast_init_done
      ]
      ast.ast2padmux:
      [
        sensor_ctrl.ast2pinmux
      ]
      ast.io_pwr_st:
      [
        sensor_ctrl.ast_status
      ]
      usbdev.usb_ref_pulse:
      [
        ast.usb_ref_pulse
      ]
      usbdev.usb_ref_val:
      [
        ast.usb_ref_val
      ]
      pinmux.dft_strap_test:
      [
        ast.dft_strap_test
      ]
      clkmgr.all_clk_byp_req:
      [
        ast.all_clk_byp_req
      ]
      clkmgr.all_clk_byp_ack:
      [
        ast.all_clk_byp_ack
      ]
      clkmgr.io_clk_byp_req:
      [
        ast.io_clk_byp_req
      ]
      clkmgr.io_clk_byp_ack:
      [
        ast.io_clk_byp_ack
      ]
      clkmgr.hi_speed_sel:
      [
        ast.ext_freq_is_96m
      ]
      clkmgr.div_step_down_req:
      [
        ast.clk_src_io_48m
      ]
      sensor_ctrl.ast_alert:
      [
        ast.alert
      ]
      alert_handler.crashdump:
      [
        rstmgr.alert_dump
      ]
      alert_handler.esc_rx:
      [
        rv_core_ibex.esc_rx
        lc_ctrl.esc_scrap_state0_rx
        lc_ctrl.esc_scrap_state1_rx
        pwrmgr.esc_rst_rx
      ]
      alert_handler.esc_tx:
      [
        rv_core_ibex.esc_tx
        lc_ctrl.esc_scrap_state0_tx
        lc_ctrl.esc_scrap_state1_tx
        pwrmgr.esc_rst_tx
      ]
      aon_timer.nmi_wdog_timer_bark:
      [
        rv_core_ibex.nmi_wdog
      ]
      csrng.csrng_cmd:
      [
        edn0.csrng_cmd
        edn1.csrng_cmd
      ]
      csrng.entropy_src_hw_if:
      [
        entropy_src.entropy_src_hw_if
      ]
      rram_ctrl.otp_key:
      [
        otp_ctrl.nvm_otp_key
      ]
      lc_ctrl.lc_nvm_rma_seed:
      [
        rram_ctrl.rma_seed
      ]
      otp_ctrl.sram_otp_key:
      [
        sram_ctrl_main.sram_otp_key
        sram_ctrl_sec.sram_otp_key
        sram_ctrl_ret.sram_otp_key
        sram_ctrl_meta.sram_otp_key
        rv_core_ibex.icache_otp_key
      ]
      pwrmgr.pwr_ast:
      [
        ast.pwrmgr
      ]
      pwrmgr.pwr_nvm:
      [
        rram_ctrl.pwrmgr
      ]
      pwrmgr.pwr_rst:
      [
        rstmgr.pwr
      ]
      pwrmgr.pwr_clk:
      [
        clkmgr.pwr
      ]
      pwrmgr.pwr_otp:
      [
        otp_ctrl.pwr_otp
      ]
      pwrmgr.pwr_lc:
      [
        lc_ctrl.pwr_lc
      ]
      pwrmgr.strap:
      [
        pinmux.strap_en
      ]
      pwrmgr.low_power:
      [
        pinmux.sleep_en
        aon_timer.sleep_mode
      ]
      pwrmgr.fetch_en:
      [
        rv_core_ibex.pwrmgr_cpu_en
      ]
      rom_ctrl.pwrmgr_data:
      [
        pwrmgr.rom_ctrl
      ]
      rom_ctrl.keymgr_data:
      [
        keymgr_dpe.rom_digest
      ]
      lc_ctrl.lc_nvm_rma_req:
      [
        otbn.lc_rma_req
        rram_ctrl.rma_req
      ]
      lc_ctrl.lc_nvm_rma_ack:
      [
        rram_ctrl.rma_ack
        otbn.lc_rma_ack
      ]
      usbdev.usb_dp_pullup:
      [
        pinmux.usbdev_dppullup_en
      ]
      usbdev.usb_dn_pullup:
      [
        pinmux.usbdev_dnpullup_en
      ]
      usbdev.usb_aon_suspend_req:
      [
        pinmux.usbdev_suspend_req
      ]
      usbdev.usb_aon_wake_ack:
      [
        pinmux.usbdev_wake_ack
      ]
      usbdev.usb_aon_bus_not_idle:
      [
        pinmux.usbdev_bus_not_idle
      ]
      usbdev.usb_aon_bus_reset:
      [
        pinmux.usbdev_bus_reset
      ]
      usbdev.usb_aon_sense_lost:
      [
        pinmux.usbdev_sense_lost
      ]
      pinmux.usbdev_wake_detect_active:
      [
        usbdev.usb_aon_wake_detect_active
      ]
      edn0.edn:
      [
        keymgr_dpe.edn
        otp_ctrl.edn
        ast.edn
        kmac.entropy
        alert_handler.edn
        aes.edn
        otbn.edn_urnd
        rv_core_ibex.edn
      ]
      edn1.edn:
      [
        otbn.edn_rnd
      ]
      otp_ctrl.otbn_otp_key:
      [
        otbn.otbn_otp_key
      ]
      otp_ctrl.keymgr_creator_root_key:
      [
        keymgr_dpe.creator_root_key
      ]
      rram_ctrl.keymgr_creator_seed:
      [
        keymgr_dpe.creator_seed
      ]
      rram_ctrl.keymgr_owner_seed:
      [
        keymgr_dpe.owner_seed
      ]
      keymgr_dpe.aes_key:
      [
        aes.keymgr_key
      ]
      keymgr_dpe.kmac_key:
      [
        kmac.keymgr_key
      ]
      keymgr_dpe.hmac_key:
      [
        hmac.keymgr_key
      ]
      keymgr_dpe.otbn_key:
      [
        otbn.keymgr_key
      ]
      kmac.app:
      [
        keymgr_dpe.kmac_app
        lc_ctrl.kmac_data
        rom_ctrl.kmac_data
        otbn.kmac_app
      ]
      kmac.en_masking:
      [
        keymgr_dpe.kmac_en_masking
      ]
      otbn.keymgr_app:
      [
        keymgr_dpe.otbn_app
      ]
      otbn.keymgr_sensitive_key:
      [
        keymgr_dpe.sensitive_key
      ]
      clkmgr.idle:
      [
        aes.idle
        hmac.idle
        kmac.idle
        otbn.idle
      ]
      pinmux.lc_jtag:
      [
        lc_ctrl.jtag
      ]
      pinmux.rv_jtag:
      [
        rv_dm.jtag
      ]
      pinmux.rram_jtag:
      [
        rram_macro.jtag
      ]
      pinmux.pinmux_hw_debug_en:
      [
        rv_dm.pinmux_hw_debug_en
      ]
      otp_ctrl.otp_lc_data:
      [
        lc_ctrl.otp_lc_data
      ]
      lc_ctrl.lc_otp_program:
      [
        otp_ctrl.lc_otp_program
      ]
      lc_ctrl.lc_keymgr_div:
      [
        keymgr_dpe.lc_keymgr_div
      ]
      lc_ctrl.strap_en_override:
      [
        pinmux.strap_en_override
      ]
      lc_ctrl.lc_dft_en:
      [
        pinmux.lc_dft_en
        ast.lc_dft_en
        pwrmgr.lc_dft_en
        rv_dm.lc_dft_en
      ]
      lc_ctrl.lc_nvm_debug_en:
      [
        rram_macro.lc_nvm_debug_en
        pinmux.lc_nvm_debug_en
      ]
      lc_ctrl.lc_hw_debug_clr:
      [
        pinmux.lc_hw_debug_clr
        rv_dm.lc_hw_debug_clr
      ]
      lc_ctrl.lc_init_done:
      [
        rv_dm.lc_init_done
      ]
      lc_ctrl.lc_hw_debug_en:
      [
        sram_ctrl_main.lc_hw_debug_en
        sram_ctrl_sec.lc_hw_debug_en
        sram_ctrl_meta.lc_hw_debug_en
        pinmux.lc_hw_debug_en
        csrng.lc_hw_debug_en
        rv_dm.lc_hw_debug_en
        clkmgr.lc_hw_debug_en
        pwrmgr.lc_hw_debug_en
      ]
      lc_ctrl.lc_cpu_en:
      [
        rv_core_ibex.lc_cpu_en
      ]
      lc_ctrl.lc_keymgr_en:
      [
        keymgr_dpe.lc_keymgr_en
      ]
      lc_ctrl.lc_escalate_en:
      [
        aes.lc_escalate_en
        kmac.lc_escalate_en
        otbn.lc_escalate_en
        otp_ctrl.lc_escalate_en
        sram_ctrl_main.lc_escalate_en
        sram_ctrl_sec.lc_escalate_en
        sram_ctrl_ret.lc_escalate_en
        sram_ctrl_meta.lc_escalate_en
        aon_timer.lc_escalate_en
        rram_ctrl.lc_escalate_en
        pinmux.lc_escalate_en
      ]
      lc_ctrl.lc_check_byp_en:
      [
        otp_ctrl.lc_check_byp_en
        pinmux.lc_check_byp_en
      ]
      lc_ctrl.lc_clk_byp_req:
      [
        clkmgr.lc_clk_byp_req
      ]
      lc_ctrl.lc_clk_byp_ack:
      [
        clkmgr.lc_clk_byp_ack
      ]
      lc_ctrl.lc_creator_seed_sw_rw_en:
      [
        otp_ctrl.lc_creator_seed_sw_rw_en
        rram_ctrl.lc_creator_seed_sw_rw_en
      ]
      lc_ctrl.lc_owner_seed_sw_rw_en:
      [
        rram_ctrl.lc_owner_seed_sw_rw_en
      ]
      lc_ctrl.lc_iso_part_sw_rd_en:
      [
        rram_ctrl.lc_iso_part_sw_rd_en
      ]
      lc_ctrl.lc_iso_part_sw_wr_en:
      [
        rram_ctrl.lc_iso_part_sw_wr_en
      ]
      lc_ctrl.lc_seed_hw_rd_en:
      [
        otp_ctrl.lc_seed_hw_rd_en
        rram_ctrl.lc_seed_hw_rd_en
      ]
      lc_ctrl.lc_rma_state:
      [
        otp_ctrl.lc_rma_state
      ]
      otp_ctrl.otp_macro:
      [
        rram_ctrl.otp_macro
      ]
      rv_plic.msip:
      [
        rv_core_ibex.irq_software
      ]
      rv_plic.irq:
      [
        rv_core_ibex.irq_external
      ]
      rv_dm.debug_req:
      [
        rv_core_ibex.debug_req
      ]
      rv_core_ibex.crash_dump:
      [
        rstmgr.cpu_dump
      ]
      rv_core_ibex.pwrmgr:
      [
        pwrmgr.pwr_cpu
      ]
      rv_core_ibex.cored_tl_h:
      [
        cheriot_mem_sys.cored_tl_d
      ]
      rv_core_ibex.corerevbm_tl:
      [
        cheriot_mem_sys.corerevbm_tl
      ]
      rv_core_ibex.cored_tag_h2d:
      [
        cheriot_mem_sys.cored_tag_h2d
      ]
      spi_device.passthrough:
      [
        spi_host0.passthrough
      ]
      rv_dm.ndmreset_req:
      [
        pwrmgr.ndmreset_req
      ]
      rstmgr.sw_rst_req:
      [
        pwrmgr.sw_rst_req
      ]
      rstmgr.por_n:
      [
        ast.rstmgr_por_n
      ]
      rram_ctrl.rram_macro:
      [
        rram_macro.rram_macro
      ]
      cheriot_mem_sys.meta_sram_tl:
      [
        sram_ctrl_meta.ram_tl
      ]
      cheriot_mem_sys.cored_tag_d2h:
      [
        rv_core_ibex.cored_tag_d2h
      ]
      rv_core_ibex.cheriot_ena:
      [
        cheriot_mem_sys.cheriot_ena
        rv_dm.cheriot_ena
      ]
      pwrmgr.wakeups:
      [
        i3c0.rstdet_wkup_req.secondary
        i3c1.rstdet_wkup_req.secondary
        sysrst_ctrl.wkup_req
        adc_ctrl.wkup_req
        pinmux.pin_wkup_req
        pinmux.usb_wkup_req
        aon_timer.wkup_req
        sensor_ctrl.wkup_req
      ]
      pwrmgr.rstreqs:
      [
        sysrst_ctrl.rst_req
        aon_timer.aon_timer_rst_req
      ]
      i3c0.rstdet_enable.primary:
      [
        i3c0.rstdet_enable.secondary
      ]
      i3c0.rstdet.primary:
      [
        i3c0.rstdet.secondary
      ]
      i3c1.rstdet_enable.primary:
      [
        i3c1.rstdet_enable.secondary
      ]
      i3c1.rstdet.primary:
      [
        i3c1.rstdet.secondary
      ]
      ast.intraip_s2p.secondary:
      [
        ast.intraip_s2p.primary
      ]
      ast.intraip_p2s.primary:
      [
        ast.intraip_p2s.secondary
      ]
      main.tl_rv_core_ibex__corei:
      [
        rv_core_ibex.corei_tl_h
      ]
      main.tl_cheriot_mem_sys__cored:
      [
        cheriot_mem_sys.cored_tl_h
      ]
      main.tl_cheriot_mem_sys__tbre:
      [
        cheriot_mem_sys.tbre_tl_h
      ]
      main.tl_rv_dm__sba:
      [
        rv_dm.sba_tl_h
      ]
      rv_dm.regs_tl_d:
      [
        main.tl_rv_dm__regs
      ]
      rv_dm.mem_tl_d:
      [
        main.tl_rv_dm__mem
      ]
      rom_ctrl.rom_tl:
      [
        main.tl_rom_ctrl__rom
      ]
      rom_ctrl.regs_tl:
      [
        main.tl_rom_ctrl__regs
      ]
      main.tl_peri:
      [
        peri.tl_main
      ]
      spi_host0.tl:
      [
        main.tl_spi_host0
      ]
      spi_host1.tl:
      [
        main.tl_spi_host1
      ]
      i3c0.tl:
      [
        main.tl_i3c0
      ]
      i3c1.tl:
      [
        main.tl_i3c1
      ]
      usbdev.tl:
      [
        main.tl_usbdev
      ]
      rram_ctrl.core_tl:
      [
        main.tl_rram_ctrl__core
      ]
      rram_macro.prim_tl:
      [
        main.tl_rram_macro__prim
      ]
      rram_ctrl.host_tl:
      [
        main.tl_rram_ctrl__host
      ]
      hmac.tl:
      [
        main.tl_hmac
      ]
      kmac.tl:
      [
        main.tl_kmac
      ]
      aes.tl:
      [
        main.tl_aes
      ]
      entropy_src.tl:
      [
        main.tl_entropy_src
      ]
      csrng.tl:
      [
        main.tl_csrng
      ]
      edn0.tl:
      [
        main.tl_edn0
      ]
      edn1.tl:
      [
        main.tl_edn1
      ]
      rv_plic.tl:
      [
        main.tl_rv_plic
      ]
      otbn.tl:
      [
        main.tl_otbn
      ]
      keymgr_dpe.tl:
      [
        main.tl_keymgr_dpe
      ]
      rv_core_ibex.cfg_tl_d:
      [
        main.tl_rv_core_ibex__cfg
      ]
      sram_ctrl_main.regs_tl:
      [
        main.tl_sram_ctrl_main__regs
      ]
      sram_ctrl_main.ram_tl:
      [
        main.tl_sram_ctrl_main__ram
      ]
      sram_ctrl_sec.regs_tl:
      [
        main.tl_sram_ctrl_sec__regs
      ]
      sram_ctrl_meta.regs_tl:
      [
        main.tl_sram_ctrl_meta__regs
      ]
      sram_ctrl_sec.ram_tl:
      [
        main.tl_sram_ctrl_sec__ram
      ]
      cheriot_mem_sys.regs_tl_d:
      [
        main.tl_cheriot_mem_sys__regs
      ]
      cheriot_mem_sys.revbm_tl_d:
      [
        main.tl_cheriot_mem_sys__revbm
      ]
      uart0.tl:
      [
        peri.tl_uart0
      ]
      uart1.tl:
      [
        peri.tl_uart1
      ]
      uart2.tl:
      [
        peri.tl_uart2
      ]
      uart3.tl:
      [
        peri.tl_uart3
      ]
      i2c0.tl:
      [
        peri.tl_i2c0
      ]
      i2c1.tl:
      [
        peri.tl_i2c1
      ]
      i2c2.tl:
      [
        peri.tl_i2c2
      ]
      gpio0.tl:
      [
        peri.tl_gpio0
      ]
      gpio1.tl:
      [
        peri.tl_gpio1
      ]
      spi_device.tl:
      [
        peri.tl_spi_device
      ]
      rv_timer.tl:
      [
        peri.tl_rv_timer
      ]
      pwrmgr.tl:
      [
        peri.tl_pwrmgr
      ]
      rstmgr.tl:
      [
        peri.tl_rstmgr
      ]
      clkmgr.tl:
      [
        peri.tl_clkmgr
      ]
      pinmux.tl:
      [
        peri.tl_pinmux
      ]
      otp_ctrl.core_tl:
      [
        peri.tl_otp_ctrl__core
      ]
      lc_ctrl.regs_tl:
      [
        peri.tl_lc_ctrl__regs
      ]
      sensor_ctrl.tl:
      [
        peri.tl_sensor_ctrl
      ]
      alert_handler.tl:
      [
        peri.tl_alert_handler
      ]
      sram_ctrl_ret.regs_tl:
      [
        peri.tl_sram_ctrl_ret__regs
      ]
      sram_ctrl_ret.ram_tl:
      [
        peri.tl_sram_ctrl_ret__ram
      ]
      aon_timer.tl:
      [
        peri.tl_aon_timer
      ]
      sysrst_ctrl.tl:
      [
        peri.tl_sysrst_ctrl
      ]
      adc_ctrl.tl:
      [
        peri.tl_adc_ctrl
      ]
      ast.tl:
      [
        peri.tl_ast
      ]
    }
    top:
    [
      clkmgr.clocks
      ast.clk_src_aon
      ast.clk_osc_byp.primary
      ast.mem_cfg.primary
      otbn.ram_cfg_imem
      otbn.ram_cfg_dmem
      i2c0.ram_cfg
      i2c1.ram_cfg
      i2c2.ram_cfg
      i3c0.ram_cfg
      i3c0.dat_cfg
      i3c0.dct_cfg
      i3c1.ram_cfg
      i3c1.dat_cfg
      i3c1.dct_cfg
      usbdev.ram_cfg
      rv_core_ibex.ram_cfg_icache_tag
      rv_core_ibex.ram_cfg_icache_data
      sram_ctrl_main.ram_cfg
      sram_ctrl_sec.ram_cfg
      sram_ctrl_meta.ram_cfg
      spi_device.ram_cfg_sys2spi
      spi_device.ram_cfg_spi2sys
      rom_ctrl.rom_cfg
      ast.mem_cfg.secondary
      sram_ctrl_ret.ram_cfg
      clkmgr.cg_en
      rstmgr.resets
      rstmgr.rst_en
      rv_core_ibex.irq_timer
      rv_core_ibex.hart_id
      rv_core_ibex.boot_addr
      pinmux.dft_jtag
      otp_ctrl.otp_broadcast
      lc_ctrl.otp_device_id
      lc_ctrl.otp_manuf_state
      keymgr_dpe.device_id
      sram_ctrl_main.otp_en_sram_ifetch
      sram_ctrl_sec.otp_en_sram_ifetch
      rv_dm.otp_dis_rv_dm_late_debug
    ]
    external:
    {
      ast.por_n: manual_in_por_n
      ast.pora_n: manual_in_pora_n
      ast.dft_scan_md: scanmode
      ast.scan_shift_en: scan_en
      ast.scan_reset_n: scan_rst_n
      ast.usb_io_pu_cal: usb_io_pu_cal
      ast.padmux2ast: padmux2ast
      ast.vx_supp: ""
      ast.obs: ""
      ast.adc_a0_a: ""
      ast.adc_a1_a: ""
      ast.ast2pad_t0_a: ast2pad_t0_a
      ast.ast2pad_t1_a: ast2pad_t1_a
      ast.clk_osc_byp.primary: clks_osc_byp
      ast.ast_pwst_h: ast_pwst_h
      pinmux.dft_hold_tap_sel: dft_hold_tap_sel
      pinmux.usb_dppullup_en: usb_dp_pullup_en
      pinmux.usb_dnpullup_en: usb_dn_pullup_en
      rram_macro.rram_test_analog: rram_test_analog
      sensor_ctrl.manual_pad_attr: sensor_ctrl_manual_pad_attr
      usbdev.usb_rx_d: ""
      usbdev.usb_tx_d: ""
      usbdev.usb_tx_se0: ""
      usbdev.usb_tx_use_d_se0: ""
      usbdev.usb_rx_enable: ""
    }
  }
  xbar:
  [
    {
      name: main
      clock_srcs:
      {
        clk_main_i: main
        clk_fixed_i: io_div4
        clk_usb_i: usb
        clk_io_i: io
      }
      clock_group: infra
      reset: rst_main_ni
      reset_connections:
      {
        rst_main_ni:
        {
          name: lc
          domain: Main
        }
        rst_fixed_ni:
        {
          name: lc_io_div4
          domain: Main
        }
        rst_usb_ni:
        {
          name: lc_usb
          domain: Main
        }
        rst_io_ni:
        {
          name: lc_io
          domain: Main
        }
      }
      domain: Main
      clock_connections:
      {
        clk_main_i: clkmgr_clocks_i.clk_main_infra
        clk_fixed_i: clkmgr_clocks_i.clk_io_div4_infra
        clk_usb_i: clkmgr_clocks_i.clk_usb_infra
        clk_io_i: clkmgr_clocks_i.clk_io_infra
      }
      connections:
      {
        rv_core_ibex.corei:
        [
          rom_ctrl.rom
          rv_dm.mem
          sram_ctrl_main.ram
          sram_ctrl_sec.ram
          rram_ctrl.host
        ]
        cheriot_mem_sys.cored:
        [
          rom_ctrl.rom
          rom_ctrl.regs
          rv_dm.mem
          rv_dm.regs
          sram_ctrl_main.ram
          sram_ctrl_sec.ram
          peri
          spi_host0
          spi_host1
          usbdev
          i3c0
          i3c1
          rram_ctrl.core
          rram_ctrl.host
          rram_macro.prim
          aes
          entropy_src
          csrng
          edn0
          edn1
          hmac
          rv_plic
          otbn
          keymgr_dpe
          kmac
          sram_ctrl_main.regs
          sram_ctrl_sec.regs
          sram_ctrl_meta.regs
          rv_core_ibex.cfg
          cheriot_mem_sys.regs
          cheriot_mem_sys.revbm
        ]
        cheriot_mem_sys.tbre:
        [
          sram_ctrl_main.ram
          sram_ctrl_sec.ram
          rram_ctrl.host
        ]
        rv_dm.sba:
        [
          rom_ctrl.rom
          rom_ctrl.regs
          rv_dm.mem
          rv_dm.regs
          sram_ctrl_main.ram
          sram_ctrl_sec.ram
          peri
          spi_host0
          spi_host1
          usbdev
          i3c0
          i3c1
          rram_ctrl.core
          rram_ctrl.host
          rram_macro.prim
          aes
          entropy_src
          csrng
          edn0
          edn1
          hmac
          rv_plic
          otbn
          keymgr_dpe
          kmac
          sram_ctrl_main.regs
          sram_ctrl_sec.regs
          sram_ctrl_meta.regs
          rv_core_ibex.cfg
          cheriot_mem_sys.regs
          cheriot_mem_sys.revbm
        ]
      }
      nodes:
      [
        {
          name: rv_core_ibex.corei
          type: host
          addr_space: hart
          clock: clk_main_i
          reset: rst_main_ni
          pipeline: false
          xbar: false
          stub: false
          inst_type: ""
          req_fifo_pass: true
          rsp_fifo_pass: true
        }
        {
          name: cheriot_mem_sys.cored
          type: host
          addr_space: hart
          clock: clk_main_i
          reset: rst_main_ni
          pipeline: false
          xbar: false
          stub: false
          inst_type: ""
          req_fifo_pass: true
          rsp_fifo_pass: true
        }
        {
          name: cheriot_mem_sys.tbre
          type: host
          addr_space: hart
          clock: clk_main_i
          reset: rst_main_ni
          pipeline: false
          xbar: false
          stub: false
          inst_type: ""
          req_fifo_pass: true
          rsp_fifo_pass: true
        }
        {
          name: rv_dm.sba
          type: host
          addr_space: hart
          clock: clk_main_i
          reset: rst_main_ni
          req_fifo_pass: false
          rsp_fifo_pass: false
          xbar: false
          stub: false
          inst_type: ""
          pipeline: true
        }
        {
          name: rv_dm.regs
          type: device
          clock: clk_main_i
          reset: rst_main_ni
          req_fifo_pass: false
          rsp_fifo_pass: false
          inst_type: rv_dm
          addr_range:
          [
            {
              base_addrs:
              {
                hart: 0x41200000
              }
              size_byte: 0x10
            }
          ]
          xbar: false
          stub: false
          pipeline: true
        }
        {
          name: rv_dm.mem
          type: device
          clock: clk_main_i
          reset: rst_main_ni
          req_fifo_pass: false
          rsp_fifo_pass: false
          inst_type: rv_dm
          addr_range:
          [
            {
              base_addrs:
              {
                hart: 0x10000
              }
              size_byte: 0x1000
            }
          ]
          xbar: false
          stub: false
          pipeline: true
        }
        {
          name: rom_ctrl.rom
          type: device
          clock: clk_main_i
          reset: rst_main_ni
          req_fifo_pass: true
          rsp_fifo_pass: false
          inst_type: rom_ctrl
          addr_range:
          [
            {
              base_addrs:
              {
                hart: 0x40000
              }
              size_byte: 0x30000
            }
          ]
          xbar: false
          stub: false
          pipeline: true
        }
        {
          name: rom_ctrl.regs
          type: device
          clock: clk_main_i
          reset: rst_main_ni
          req_fifo_pass: false
          rsp_fifo_pass: false
          inst_type: rom_ctrl
          addr_range:
          [
            {
              base_addrs:
              {
                hart: 0x411e0000
              }
              size_byte: 0x80
            }
          ]
          xbar: false
          stub: false
          pipeline: true
        }
        {
          name: peri
          type: device
          clock: clk_fixed_i
          reset: rst_fixed_ni
          req_fifo_pass: false
          rsp_fifo_pass: false
          xbar: true
          stub: false
          pipeline: true
          addr_space: hart
          addr_range:
          [
            {
              base_addrs:
              {
                hart: 0x40000000
              }
              size_byte: 0x200000
            }
            {
              base_addrs:
              {
                hart: 0x40400000
              }
              size_byte: 0x400000
            }
          ]
        }
        {
          name: spi_host0
          type: device
          clock: clk_io_i
          reset: rst_io_ni
          req_fifo_pass: false
          rsp_fifo_pass: false
          inst_type: spi_host
          addr_range:
          [
            {
              base_addrs:
              {
                hart: 0x40300000
              }
              size_byte: 0x40
            }
          ]
          xbar: false
          stub: false
          pipeline: true
        }
        {
          name: spi_host1
          type: device
          clock: clk_io_i
          reset: rst_io_ni
          req_fifo_pass: false
          rsp_fifo_pass: false
          inst_type: spi_host
          addr_range:
          [
            {
              base_addrs:
              {
                hart: 0x40310000
              }
              size_byte: 0x40
            }
          ]
          xbar: false
          stub: false
          pipeline: true
        }
        {
          name: i3c0
          type: device
          clock: clk_io_i
          reset: rst_io_ni
          req_fifo_pass: false
          rsp_fifo_pass: false
          inst_type: i3c
          addr_range:
          [
            {
              base_addrs:
              {
                hart: 0x40330000
              }
              size_byte: 0x2000
            }
          ]
          xbar: false
          stub: false
          pipeline: true
        }
        {
          name: i3c1
          type: device
          clock: clk_io_i
          reset: rst_io_ni
          req_fifo_pass: false
          rsp_fifo_pass: false
          inst_type: i3c
          addr_range:
          [
            {
              base_addrs:
              {
                hart: 0x40340000
              }
              size_byte: 0x2000
            }
          ]
          xbar: false
          stub: false
          pipeline: true
        }
        {
          name: usbdev
          type: device
          clock: clk_usb_i
          reset: rst_usb_ni
          req_fifo_pass: false
          rsp_fifo_pass: false
          inst_type: usbdev
          addr_range:
          [
            {
              base_addrs:
              {
                hart: 0x40320000
              }
              size_byte: 0x1000
            }
          ]
          xbar: false
          stub: false
          pipeline: true
        }
        {
          name: rram_ctrl.core
          type: device
          clock: clk_main_i
          reset: rst_main_ni
          req_fifo_pass: false
          rsp_fifo_pass: false
          inst_type: rram_ctrl
          addr_range:
          [
            {
              base_addrs:
              {
                hart: 0x41010000
              }
              size_byte: 0x400
            }
          ]
          xbar: false
          stub: false
          pipeline: true
        }
        {
          name: rram_macro.prim
          type: device
          clock: clk_main_i
          reset: rst_main_ni
          req_fifo_pass: false
          rsp_fifo_pass: false
          inst_type: rram_macro
          addr_range:
          [
            {
              base_addrs:
              {
                hart: 0x41018000
              }
              size_byte: 0x10
            }
          ]
          xbar: false
          stub: false
          pipeline: true
        }
        {
          name: rram_ctrl.host
          type: device
          clock: clk_main_i
          reset: rst_main_ni
          req_fifo_pass: false
          rsp_fifo_pass: false
          inst_type: rram_ctrl
          addr_range:
          [
            {
              base_addrs:
              {
                hart: 0x30000000
              }
              size_byte: 0x200000
            }
          ]
          xbar: false
          stub: false
          pipeline: true
        }
        {
          name: hmac
          type: device
          clock: clk_main_i
          reset: rst_main_ni
          req_fifo_pass: false
          rsp_fifo_pass: false
          inst_type: hmac
          addr_range:
          [
            {
              base_addrs:
              {
                hart: 0x41110000
              }
              size_byte: 0x2000
            }
          ]
          xbar: false
          stub: false
          pipeline: true
        }
        {
          name: kmac
          type: device
          clock: clk_main_i
          reset: rst_main_ni
          req_fifo_pass: false
          rsp_fifo_pass: false
          inst_type: kmac
          addr_range:
          [
            {
              base_addrs:
              {
                hart: 0x41120000
              }
              size_byte: 0x1000
            }
          ]
          xbar: false
          stub: false
          pipeline: true
        }
        {
          name: aes
          type: device
          clock: clk_main_i
          reset: rst_main_ni
          req_fifo_pass: false
          rsp_fifo_pass: false
          inst_type: aes
          addr_range:
          [
            {
              base_addrs:
              {
                hart: 0x41100000
              }
              size_byte: 0x100
            }
          ]
          xbar: false
          stub: false
          pipeline: true
        }
        {
          name: entropy_src
          type: device
          clock: clk_main_i
          reset: rst_main_ni
          req_fifo_pass: false
          rsp_fifo_pass: false
          inst_type: entropy_src
          addr_range:
          [
            {
              base_addrs:
              {
                hart: 0x41160000
              }
              size_byte: 0x100
            }
          ]
          xbar: false
          stub: false
          pipeline: true
        }
        {
          name: csrng
          type: device
          clock: clk_main_i
          reset: rst_main_ni
          req_fifo_pass: false
          rsp_fifo_pass: false
          inst_type: csrng
          addr_range:
          [
            {
              base_addrs:
              {
                hart: 0x41150000
              }
              size_byte: 0x100
            }
          ]
          xbar: false
          stub: false
          pipeline: true
        }
        {
          name: edn0
          type: device
          clock: clk_main_i
          reset: rst_main_ni
          req_fifo_pass: false
          rsp_fifo_pass: false
          inst_type: edn
          addr_range:
          [
            {
              base_addrs:
              {
                hart: 0x41170000
              }
              size_byte: 0x80
            }
          ]
          xbar: false
          stub: false
          pipeline: true
        }
        {
          name: edn1
          type: device
          clock: clk_main_i
          reset: rst_main_ni
          req_fifo_pass: false
          rsp_fifo_pass: false
          inst_type: edn
          addr_range:
          [
            {
              base_addrs:
              {
                hart: 0x41180000
              }
              size_byte: 0x80
            }
          ]
          xbar: false
          stub: false
          pipeline: true
        }
        {
          name: rv_plic
          type: device
          clock: clk_main_i
          reset: rst_main_ni
          inst_type: rv_plic
          req_fifo_pass: false
          rsp_fifo_pass: false
          addr_range:
          [
            {
              base_addrs:
              {
                hart: 0x48000000
              }
              size_byte: 0x8000000
            }
          ]
          xbar: false
          stub: false
          pipeline: true
        }
        {
          name: otbn
          type: device
          clock: clk_main_i
          reset: rst_main_ni
          req_fifo_pass: false
          rsp_fifo_pass: false
          inst_type: otbn
          addr_range:
          [
            {
              base_addrs:
              {
                hart: 0x41130000
              }
              size_byte: 0x10000
            }
          ]
          xbar: false
          stub: false
          pipeline: true
        }
        {
          name: keymgr_dpe
          type: device
          clock: clk_main_i
          reset: rst_main_ni
          req_fifo_pass: false
          rsp_fifo_pass: false
          inst_type: keymgr_dpe
          addr_range:
          [
            {
              base_addrs:
              {
                hart: 0x41140000
              }
              size_byte: 0x200
            }
          ]
          xbar: false
          stub: false
          pipeline: true
        }
        {
          name: rv_core_ibex.cfg
          type: device
          clock: clk_main_i
          reset: rst_main_ni
          req_fifo_pass: false
          rsp_fifo_pass: false
          inst_type: rv_core_ibex
          addr_range:
          [
            {
              base_addrs:
              {
                hart: 0x411f0000
              }
              size_byte: 0x100
            }
          ]
          xbar: false
          stub: false
          pipeline: true
        }
        {
          name: sram_ctrl_main.regs
          type: device
          clock: clk_main_i
          reset: rst_main_ni
          req_fifo_pass: false
          rsp_fifo_pass: false
          inst_type: sram_ctrl
          addr_range:
          [
            {
              base_addrs:
              {
                hart: 0x411c0000
              }
              size_byte: 0x40
            }
          ]
          xbar: false
          stub: false
          pipeline: true
        }
        {
          name: sram_ctrl_main.ram
          type: device
          clock: clk_main_i
          reset: rst_main_ni
          pipeline: false
          inst_type: sram_ctrl
          addr_range:
          [
            {
              base_addrs:
              {
                hart: 0x10000000
              }
              size_byte: 0x20000
            }
          ]
          xbar: false
          stub: false
          req_fifo_pass: true
        }
        {
          name: sram_ctrl_sec.regs
          type: device
          clock: clk_main_i
          reset: rst_main_ni
          req_fifo_pass: false
          rsp_fifo_pass: false
          inst_type: sram_ctrl
          addr_range:
          [
            {
              base_addrs:
              {
                hart: 0x411d0000
              }
              size_byte: 0x40
            }
          ]
          xbar: false
          stub: false
          pipeline: true
        }
        {
          name: sram_ctrl_meta.regs
          type: device
          clock: clk_main_i
          reset: rst_main_ni
          req_fifo_pass: false
          rsp_fifo_pass: false
          inst_type: sram_ctrl
          addr_range:
          [
            {
              base_addrs:
              {
                hart: 0x411a0000
              }
              size_byte: 0x40
            }
          ]
          xbar: false
          stub: false
          pipeline: true
        }
        {
          name: sram_ctrl_sec.ram
          type: device
          clock: clk_main_i
          reset: rst_main_ni
          pipeline: false
          inst_type: sram_ctrl
          addr_range:
          [
            {
              base_addrs:
              {
                hart: 0x10020000
              }
              size_byte: 0x10000
            }
          ]
          xbar: false
          stub: false
          req_fifo_pass: true
        }
        {
          name: cheriot_mem_sys.regs
          type: device
          clock: clk_main_i
          reset: rst_main_ni
          req_fifo_pass: false
          rsp_fifo_pass: false
          inst_type: cheriot_mem_sys
          addr_range:
          [
            {
              base_addrs:
              {
                hart: 0x411b0000
              }
              size_byte: 0x40
            }
          ]
          xbar: false
          stub: false
          pipeline: true
        }
        {
          name: cheriot_mem_sys.revbm
          type: device
          clock: clk_main_i
          reset: rst_main_ni
          req_fifo_pass: false
          rsp_fifo_pass: false
          inst_type: cheriot_mem_sys
          addr_range:
          [
            {
              base_addrs:
              {
                hart: 0x11000000
              }
              size_byte: 0xc00
            }
          ]
          xbar: false
          stub: false
          pipeline: true
        }
      ]
      addr_spaces:
      [
        hart
      ]
      clock: clk_main_i
      type: xbar
      inter_signal_list:
      [
        {
          name: tl_rv_core_ibex__corei
          struct: tl
          package: tlul_pkg
          type: req_rsp
          act: rsp
          inst_name: main
          width: 1
          default: ""
          end_idx: -1
          top_type: one-to-one
          top_signame: main_tl_rv_core_ibex__corei
          index: -1
        }
        {
          name: tl_cheriot_mem_sys__cored
          struct: tl
          package: tlul_pkg
          type: req_rsp
          act: rsp
          inst_name: main
          width: 1
          default: ""
          end_idx: -1
          top_type: one-to-one
          top_signame: main_tl_cheriot_mem_sys__cored
          index: -1
        }
        {
          name: tl_cheriot_mem_sys__tbre
          struct: tl
          package: tlul_pkg
          type: req_rsp
          act: rsp
          inst_name: main
          width: 1
          default: ""
          end_idx: -1
          top_type: one-to-one
          top_signame: main_tl_cheriot_mem_sys__tbre
          index: -1
        }
        {
          name: tl_rv_dm__sba
          struct: tl
          package: tlul_pkg
          type: req_rsp
          act: rsp
          inst_name: main
          width: 1
          default: ""
          end_idx: -1
          top_type: one-to-one
          top_signame: main_tl_rv_dm__sba
          index: -1
        }
        {
          name: tl_rv_dm__regs
          struct: tl
          package: tlul_pkg
          type: req_rsp
          act: req
          inst_name: main
          width: 1
          default: ""
          domain: Main
          top_signame: rv_dm_regs_tl_d
          index: -1
        }
        {
          name: tl_rv_dm__mem
          struct: tl
          package: tlul_pkg
          type: req_rsp
          act: req
          inst_name: main
          width: 1
          default: ""
          domain: Main
          top_signame: rv_dm_mem_tl_d
          index: -1
        }
        {
          name: tl_rom_ctrl__rom
          struct: tl
          package: tlul_pkg
          type: req_rsp
          act: req
          inst_name: main
          width: 1
          default: ""
          domain: Main
          top_signame: rom_ctrl_rom_tl
          index: -1
        }
        {
          name: tl_rom_ctrl__regs
          struct: tl
          package: tlul_pkg
          type: req_rsp
          act: req
          inst_name: main
          width: 1
          default: ""
          domain: Main
          top_signame: rom_ctrl_regs_tl
          index: -1
        }
        {
          name: tl_peri
          struct: tl
          package: tlul_pkg
          type: req_rsp
          act: req
          inst_name: main
          width: 1
          default: ""
          end_idx: -1
          top_type: one-to-one
          top_signame: main_tl_peri
          index: -1
        }
        {
          name: tl_spi_host0
          struct: tl
          package: tlul_pkg
          type: req_rsp
          act: req
          inst_name: main
          width: 1
          default: ""
          domain: Main
          top_signame: spi_host0_tl
          index: -1
        }
        {
          name: tl_spi_host1
          struct: tl
          package: tlul_pkg
          type: req_rsp
          act: req
          inst_name: main
          width: 1
          default: ""
          domain: Main
          top_signame: spi_host1_tl
          index: -1
        }
        {
          name: tl_i3c0
          struct: tl
          package: tlul_pkg
          type: req_rsp
          act: req
          inst_name: main
          width: 1
          default: ""
          domain: Main
          top_signame: i3c0_tl
          index: -1
        }
        {
          name: tl_i3c1
          struct: tl
          package: tlul_pkg
          type: req_rsp
          act: req
          inst_name: main
          width: 1
          default: ""
          domain: Main
          top_signame: i3c1_tl
          index: -1
        }
        {
          name: tl_usbdev
          struct: tl
          package: tlul_pkg
          type: req_rsp
          act: req
          inst_name: main
          width: 1
          default: ""
          domain: Main
          top_signame: usbdev_tl
          index: -1
        }
        {
          name: tl_rram_ctrl__core
          struct: tl
          package: tlul_pkg
          type: req_rsp
          act: req
          inst_name: main
          width: 1
          default: ""
          domain: Main
          top_signame: rram_ctrl_core_tl
          index: -1
        }
        {
          name: tl_rram_macro__prim
          struct: tl
          package: tlul_pkg
          type: req_rsp
          act: req
          inst_name: main
          width: 1
          default: ""
          domain: Main
          top_signame: rram_macro_prim_tl
          index: -1
        }
        {
          name: tl_rram_ctrl__host
          struct: tl
          package: tlul_pkg
          type: req_rsp
          act: req
          inst_name: main
          width: 1
          default: ""
          domain: Main
          top_signame: rram_ctrl_host_tl
          index: -1
        }
        {
          name: tl_hmac
          struct: tl
          package: tlul_pkg
          type: req_rsp
          act: req
          inst_name: main
          width: 1
          default: ""
          domain: Main
          top_signame: hmac_tl
          index: -1
        }
        {
          name: tl_kmac
          struct: tl
          package: tlul_pkg
          type: req_rsp
          act: req
          inst_name: main
          width: 1
          default: ""
          domain: Main
          top_signame: kmac_tl
          index: -1
        }
        {
          name: tl_aes
          struct: tl
          package: tlul_pkg
          type: req_rsp
          act: req
          inst_name: main
          width: 1
          default: ""
          domain: Main
          top_signame: aes_tl
          index: -1
        }
        {
          name: tl_entropy_src
          struct: tl
          package: tlul_pkg
          type: req_rsp
          act: req
          inst_name: main
          width: 1
          default: ""
          domain: Main
          top_signame: entropy_src_tl
          index: -1
        }
        {
          name: tl_csrng
          struct: tl
          package: tlul_pkg
          type: req_rsp
          act: req
          inst_name: main
          width: 1
          default: ""
          domain: Main
          top_signame: csrng_tl
          index: -1
        }
        {
          name: tl_edn0
          struct: tl
          package: tlul_pkg
          type: req_rsp
          act: req
          inst_name: main
          width: 1
          default: ""
          domain: Main
          top_signame: edn0_tl
          index: -1
        }
        {
          name: tl_edn1
          struct: tl
          package: tlul_pkg
          type: req_rsp
          act: req
          inst_name: main
          width: 1
          default: ""
          domain: Main
          top_signame: edn1_tl
          index: -1
        }
        {
          name: tl_rv_plic
          struct: tl
          package: tlul_pkg
          type: req_rsp
          act: req
          inst_name: main
          width: 1
          default: ""
          domain: Main
          top_signame: rv_plic_tl
          index: -1
        }
        {
          name: tl_otbn
          struct: tl
          package: tlul_pkg
          type: req_rsp
          act: req
          inst_name: main
          width: 1
          default: ""
          domain: Main
          top_signame: otbn_tl
          index: -1
        }
        {
          name: tl_keymgr_dpe
          struct: tl
          package: tlul_pkg
          type: req_rsp
          act: req
          inst_name: main
          width: 1
          default: ""
          domain: Main
          top_signame: keymgr_dpe_tl
          index: -1
        }
        {
          name: tl_rv_core_ibex__cfg
          struct: tl
          package: tlul_pkg
          type: req_rsp
          act: req
          inst_name: main
          width: 1
          default: ""
          domain: Main
          top_signame: rv_core_ibex_cfg_tl_d
          index: -1
        }
        {
          name: tl_sram_ctrl_main__regs
          struct: tl
          package: tlul_pkg
          type: req_rsp
          act: req
          inst_name: main
          width: 1
          default: ""
          domain: Main
          top_signame: sram_ctrl_main_regs_tl
          index: -1
        }
        {
          name: tl_sram_ctrl_main__ram
          struct: tl
          package: tlul_pkg
          type: req_rsp
          act: req
          inst_name: main
          width: 1
          default: ""
          domain: Main
          top_signame: sram_ctrl_main_ram_tl
          index: -1
        }
        {
          name: tl_sram_ctrl_sec__regs
          struct: tl
          package: tlul_pkg
          type: req_rsp
          act: req
          inst_name: main
          width: 1
          default: ""
          domain: Main
          top_signame: sram_ctrl_sec_regs_tl
          index: -1
        }
        {
          name: tl_sram_ctrl_meta__regs
          struct: tl
          package: tlul_pkg
          type: req_rsp
          act: req
          inst_name: main
          width: 1
          default: ""
          domain: Main
          top_signame: sram_ctrl_meta_regs_tl
          index: -1
        }
        {
          name: tl_sram_ctrl_sec__ram
          struct: tl
          package: tlul_pkg
          type: req_rsp
          act: req
          inst_name: main
          width: 1
          default: ""
          domain: Main
          top_signame: sram_ctrl_sec_ram_tl
          index: -1
        }
        {
          name: tl_cheriot_mem_sys__regs
          struct: tl
          package: tlul_pkg
          type: req_rsp
          act: req
          inst_name: main
          width: 1
          default: ""
          domain: Main
          top_signame: cheriot_mem_sys_regs_tl_d
          index: -1
        }
        {
          name: tl_cheriot_mem_sys__revbm
          struct: tl
          package: tlul_pkg
          type: req_rsp
          act: req
          inst_name: main
          width: 1
          default: ""
          domain: Main
          top_signame: cheriot_mem_sys_revbm_tl_d
          index: -1
        }
      ]
    }
    {
      name: peri
      clock_srcs:
      {
        clk_peri_i: io_div4
      }
      clock_group: infra
      reset: rst_peri_ni
      reset_connections:
      {
        rst_peri_ni:
        {
          name: lc_io_div4
          domain: Main
        }
      }
      domain: Main
      clock_connections:
      {
        clk_peri_i: clkmgr_clocks_i.clk_io_div4_infra
      }
      connections:
      {
        main:
        [
          uart0
          uart1
          uart2
          uart3
          i2c0
          i2c1
          i2c2
          gpio0
          gpio1
          spi_device
          rv_timer
          pwrmgr
          rstmgr
          clkmgr
          pinmux
          otp_ctrl.core
          lc_ctrl.regs
          sensor_ctrl
          alert_handler
          ast
          sram_ctrl_ret.ram
          sram_ctrl_ret.regs
          aon_timer
          adc_ctrl
          sysrst_ctrl
        ]
      }
      nodes:
      [
        {
          name: main
          type: host
          addr_space: hart
          clock: clk_peri_i
          reset: rst_peri_ni
          xbar: true
          pipeline: false
          stub: false
          inst_type: ""
          req_fifo_pass: true
          rsp_fifo_pass: true
        }
        {
          name: uart0
          type: device
          clock: clk_peri_i
          reset: rst_peri_ni
          pipeline: false
          inst_type: uart
          addr_range:
          [
            {
              base_addrs:
              {
                hart: 0x40000000
              }
              size_byte: 0x40
            }
          ]
          xbar: false
          stub: false
          req_fifo_pass: true
        }
        {
          name: uart1
          type: device
          clock: clk_peri_i
          reset: rst_peri_ni
          pipeline: false
          inst_type: uart
          addr_range:
          [
            {
              base_addrs:
              {
                hart: 0x40010000
              }
              size_byte: 0x40
            }
          ]
          xbar: false
          stub: false
          req_fifo_pass: true
        }
        {
          name: uart2
          type: device
          clock: clk_peri_i
          reset: rst_peri_ni
          pipeline: false
          inst_type: uart
          addr_range:
          [
            {
              base_addrs:
              {
                hart: 0x40020000
              }
              size_byte: 0x40
            }
          ]
          xbar: false
          stub: false
          req_fifo_pass: true
        }
        {
          name: uart3
          type: device
          clock: clk_peri_i
          reset: rst_peri_ni
          pipeline: false
          inst_type: uart
          addr_range:
          [
            {
              base_addrs:
              {
                hart: 0x40030000
              }
              size_byte: 0x40
            }
          ]
          xbar: false
          stub: false
          req_fifo_pass: true
        }
        {
          name: i2c0
          type: device
          clock: clk_peri_i
          reset: rst_peri_ni
          pipeline: false
          inst_type: i2c
          addr_range:
          [
            {
              base_addrs:
              {
                hart: 0x40080000
              }
              size_byte: 0x80
            }
          ]
          xbar: false
          stub: false
          req_fifo_pass: true
        }
        {
          name: i2c1
          type: device
          clock: clk_peri_i
          reset: rst_peri_ni
          pipeline: false
          inst_type: i2c
          addr_range:
          [
            {
              base_addrs:
              {
                hart: 0x40090000
              }
              size_byte: 0x80
            }
          ]
          xbar: false
          stub: false
          req_fifo_pass: true
        }
        {
          name: i2c2
          type: device
          clock: clk_peri_i
          reset: rst_peri_ni
          pipeline: false
          inst_type: i2c
          addr_range:
          [
            {
              base_addrs:
              {
                hart: 0x400a0000
              }
              size_byte: 0x80
            }
          ]
          xbar: false
          stub: false
          req_fifo_pass: true
        }
        {
          name: gpio0
          type: device
          clock: clk_peri_i
          reset: rst_peri_ni
          pipeline: false
          inst_type: gpio
          addr_range:
          [
            {
              base_addrs:
              {
                hart: 0x40040000
              }
              size_byte: 0x400
            }
          ]
          xbar: false
          stub: false
          req_fifo_pass: true
        }
        {
          name: gpio1
          type: device
          clock: clk_peri_i
          reset: rst_peri_ni
          pipeline: false
          inst_type: gpio
          addr_range:
          [
            {
              base_addrs:
              {
                hart: 0x40050000
              }
              size_byte: 0x400
            }
          ]
          xbar: false
          stub: false
          req_fifo_pass: true
        }
        {
          name: spi_device
          type: device
          clock: clk_peri_i
          reset: rst_peri_ni
          pipeline: false
          inst_type: spi_device
          addr_range:
          [
            {
              base_addrs:
              {
                hart: 0x40060000
              }
              size_byte: 0x2000
            }
          ]
          xbar: false
          stub: false
          req_fifo_pass: true
        }
        {
          name: rv_timer
          type: device
          clock: clk_peri_i
          reset: rst_peri_ni
          pipeline: false
          inst_type: rv_timer
          addr_range:
          [
            {
              base_addrs:
              {
                hart: 0x40100000
              }
              size_byte: 0x200
            }
          ]
          xbar: false
          stub: false
          req_fifo_pass: true
        }
        {
          name: pwrmgr
          type: device
          clock: clk_peri_i
          reset: rst_peri_ni
          pipeline: false
          inst_type: pwrmgr
          addr_range:
          [
            {
              base_addrs:
              {
                hart: 0x40400000
              }
              size_byte: 0x80
            }
          ]
          xbar: false
          stub: false
          req_fifo_pass: true
        }
        {
          name: rstmgr
          type: device
          clock: clk_peri_i
          reset: rst_peri_ni
          pipeline: false
          inst_type: rstmgr
          addr_range:
          [
            {
              base_addrs:
              {
                hart: 0x40410000
              }
              size_byte: 0x80
            }
          ]
          xbar: false
          stub: false
          req_fifo_pass: true
        }
        {
          name: clkmgr
          type: device
          clock: clk_peri_i
          reset: rst_peri_ni
          pipeline: false
          inst_type: clkmgr
          addr_range:
          [
            {
              base_addrs:
              {
                hart: 0x40420000
              }
              size_byte: 0x80
            }
          ]
          xbar: false
          stub: false
          req_fifo_pass: true
        }
        {
          name: pinmux
          type: device
          clock: clk_peri_i
          reset: rst_peri_ni
          pipeline: false
          inst_type: pinmux
          addr_range:
          [
            {
              base_addrs:
              {
                hart: 0x40460000
              }
              size_byte: 0x1000
            }
          ]
          xbar: false
          stub: false
          req_fifo_pass: true
        }
        {
          name: otp_ctrl.core
          type: device
          clock: clk_peri_i
          reset: rst_peri_ni
          pipeline: false
          inst_type: otp_ctrl
          addr_range:
          [
            {
              base_addrs:
              {
                hart: 0x40130000
              }
              size_byte: 0x2000
            }
          ]
          xbar: false
          stub: false
          req_fifo_pass: true
        }
        {
          name: lc_ctrl.regs
          type: device
          clock: clk_peri_i
          reset: rst_peri_ni
          pipeline: false
          inst_type: lc_ctrl
          addr_range:
          [
            {
              base_addrs:
              {
                hart: 0x40140000
              }
              size_byte: 0x100
            }
          ]
          xbar: false
          stub: false
          req_fifo_pass: true
        }
        {
          name: sensor_ctrl
          type: device
          clock: clk_peri_i
          reset: rst_peri_ni
          pipeline: false
          inst_type: sensor_ctrl
          addr_range:
          [
            {
              base_addrs:
              {
                hart: 0x40490000
              }
              size_byte: 0x80
            }
          ]
          xbar: false
          stub: false
          req_fifo_pass: true
        }
        {
          name: alert_handler
          type: device
          clock: clk_peri_i
          reset: rst_peri_ni
          pipeline: false
          inst_type: alert_handler
          addr_range:
          [
            {
              base_addrs:
              {
                hart: 0x40150000
              }
              size_byte: 0x800
            }
          ]
          xbar: false
          stub: false
          req_fifo_pass: true
        }
        {
          name: sram_ctrl_ret.regs
          type: device
          clock: clk_peri_i
          reset: rst_peri_ni
          pipeline: false
          inst_type: sram_ctrl
          addr_range:
          [
            {
              base_addrs:
              {
                hart: 0x40500000
              }
              size_byte: 0x40
            }
          ]
          xbar: false
          stub: false
          req_fifo_pass: true
        }
        {
          name: sram_ctrl_ret.ram
          type: device
          clock: clk_peri_i
          reset: rst_peri_ni
          pipeline: false
          inst_type: sram_ctrl
          addr_range:
          [
            {
              base_addrs:
              {
                hart: 0x40600000
              }
              size_byte: 0x2000
            }
          ]
          xbar: false
          stub: false
          req_fifo_pass: true
        }
        {
          name: aon_timer
          type: device
          clock: clk_peri_i
          reset: rst_peri_ni
          pipeline: false
          inst_type: aon_timer
          addr_range:
          [
            {
              base_addrs:
              {
                hart: 0x40470000
              }
              size_byte: 0x40
            }
          ]
          xbar: false
          stub: false
          req_fifo_pass: true
        }
        {
          name: sysrst_ctrl
          type: device
          clock: clk_peri_i
          reset: rst_peri_ni
          pipeline: false
          inst_type: sysrst_ctrl
          addr_range:
          [
            {
              base_addrs:
              {
                hart: 0x40430000
              }
              size_byte: 0x100
            }
          ]
          xbar: false
          stub: false
          req_fifo_pass: true
        }
        {
          name: adc_ctrl
          type: device
          clock: clk_peri_i
          reset: rst_peri_ni
          pipeline: false
          inst_type: adc_ctrl
          addr_range:
          [
            {
              base_addrs:
              {
                hart: 0x40440000
              }
              size_byte: 0x80
            }
          ]
          xbar: false
          stub: false
          req_fifo_pass: true
        }
        {
          name: ast
          type: device
          clock: clk_peri_i
          reset: rst_peri_ni
          pipeline: false
          inst_type: ast
          addr_range:
          [
            {
              base_addrs:
              {
                hart: 0x40480000
              }
              size_byte: 0x400
            }
          ]
          xbar: false
          stub: false
          req_fifo_pass: true
        }
      ]
      addr_spaces:
      [
        hart
      ]
      clock: clk_peri_i
      type: xbar
      inter_signal_list:
      [
        {
          name: tl_main
          struct: tl
          package: tlul_pkg
          type: req_rsp
          act: rsp
          inst_name: peri
          width: 1
          default: ""
          domain: Main
          top_signame: main_tl_peri
          index: -1
        }
        {
          name: tl_uart0
          struct: tl
          package: tlul_pkg
          type: req_rsp
          act: req
          inst_name: peri
          width: 1
          default: ""
          domain: Main
          top_signame: uart0_tl
          index: -1
        }
        {
          name: tl_uart1
          struct: tl
          package: tlul_pkg
          type: req_rsp
          act: req
          inst_name: peri
          width: 1
          default: ""
          domain: Main
          top_signame: uart1_tl
          index: -1
        }
        {
          name: tl_uart2
          struct: tl
          package: tlul_pkg
          type: req_rsp
          act: req
          inst_name: peri
          width: 1
          default: ""
          domain: Main
          top_signame: uart2_tl
          index: -1
        }
        {
          name: tl_uart3
          struct: tl
          package: tlul_pkg
          type: req_rsp
          act: req
          inst_name: peri
          width: 1
          default: ""
          domain: Main
          top_signame: uart3_tl
          index: -1
        }
        {
          name: tl_i2c0
          struct: tl
          package: tlul_pkg
          type: req_rsp
          act: req
          inst_name: peri
          width: 1
          default: ""
          domain: Main
          top_signame: i2c0_tl
          index: -1
        }
        {
          name: tl_i2c1
          struct: tl
          package: tlul_pkg
          type: req_rsp
          act: req
          inst_name: peri
          width: 1
          default: ""
          domain: Main
          top_signame: i2c1_tl
          index: -1
        }
        {
          name: tl_i2c2
          struct: tl
          package: tlul_pkg
          type: req_rsp
          act: req
          inst_name: peri
          width: 1
          default: ""
          domain: Main
          top_signame: i2c2_tl
          index: -1
        }
        {
          name: tl_gpio0
          struct: tl
          package: tlul_pkg
          type: req_rsp
          act: req
          inst_name: peri
          width: 1
          default: ""
          domain: Main
          top_signame: gpio0_tl
          index: -1
        }
        {
          name: tl_gpio1
          struct: tl
          package: tlul_pkg
          type: req_rsp
          act: req
          inst_name: peri
          width: 1
          default: ""
          domain: Main
          top_signame: gpio1_tl
          index: -1
        }
        {
          name: tl_spi_device
          struct: tl
          package: tlul_pkg
          type: req_rsp
          act: req
          inst_name: peri
          width: 1
          default: ""
          domain: Main
          top_signame: spi_device_tl
          index: -1
        }
        {
          name: tl_rv_timer
          struct: tl
          package: tlul_pkg
          type: req_rsp
          act: req
          inst_name: peri
          width: 1
          default: ""
          domain: Main
          top_signame: rv_timer_tl
          index: -1
        }
        {
          name: tl_pwrmgr
          struct: tl
          package: tlul_pkg
          type: req_rsp
          act: req
          inst_name: peri
          width: 1
          default: ""
          domain: Main
          top_signame: pwrmgr_tl
          index: -1
          external: true
          conn_type: false
        }
        {
          name: tl_rstmgr
          struct: tl
          package: tlul_pkg
          type: req_rsp
          act: req
          inst_name: peri
          width: 1
          default: ""
          domain: Main
          top_signame: rstmgr_tl
          index: -1
          external: true
          conn_type: false
        }
        {
          name: tl_clkmgr
          struct: tl
          package: tlul_pkg
          type: req_rsp
          act: req
          inst_name: peri
          width: 1
          default: ""
          domain: Main
          top_signame: clkmgr_tl
          index: -1
          external: true
          conn_type: false
        }
        {
          name: tl_pinmux
          struct: tl
          package: tlul_pkg
          type: req_rsp
          act: req
          inst_name: peri
          width: 1
          default: ""
          domain: Main
          top_signame: pinmux_tl
          index: -1
          external: true
          conn_type: false
        }
        {
          name: tl_otp_ctrl__core
          struct: tl
          package: tlul_pkg
          type: req_rsp
          act: req
          inst_name: peri
          width: 1
          default: ""
          domain: Main
          top_signame: otp_ctrl_core_tl
          index: -1
        }
        {
          name: tl_lc_ctrl__regs
          struct: tl
          package: tlul_pkg
          type: req_rsp
          act: req
          inst_name: peri
          width: 1
          default: ""
          domain: Main
          top_signame: lc_ctrl_regs_tl
          index: -1
        }
        {
          name: tl_sensor_ctrl
          struct: tl
          package: tlul_pkg
          type: req_rsp
          act: req
          inst_name: peri
          width: 1
          default: ""
          domain: Main
          top_signame: sensor_ctrl_tl
          index: -1
          external: true
          conn_type: false
        }
        {
          name: tl_alert_handler
          struct: tl
          package: tlul_pkg
          type: req_rsp
          act: req
          inst_name: peri
          width: 1
          default: ""
          domain: Main
          top_signame: alert_handler_tl
          index: -1
        }
        {
          name: tl_sram_ctrl_ret__regs
          struct: tl
          package: tlul_pkg
          type: req_rsp
          act: req
          inst_name: peri
          width: 1
          default: ""
          domain: Main
          top_signame: sram_ctrl_ret_regs_tl
          index: -1
          external: true
          conn_type: false
        }
        {
          name: tl_sram_ctrl_ret__ram
          struct: tl
          package: tlul_pkg
          type: req_rsp
          act: req
          inst_name: peri
          width: 1
          default: ""
          domain: Main
          top_signame: sram_ctrl_ret_ram_tl
          index: -1
          external: true
          conn_type: false
        }
        {
          name: tl_aon_timer
          struct: tl
          package: tlul_pkg
          type: req_rsp
          act: req
          inst_name: peri
          width: 1
          default: ""
          domain: Main
          top_signame: aon_timer_tl
          index: -1
          external: true
          conn_type: false
        }
        {
          name: tl_sysrst_ctrl
          struct: tl
          package: tlul_pkg
          type: req_rsp
          act: req
          inst_name: peri
          width: 1
          default: ""
          domain: Main
          top_signame: sysrst_ctrl_tl
          index: -1
          external: true
          conn_type: false
        }
        {
          name: tl_adc_ctrl
          struct: tl
          package: tlul_pkg
          type: req_rsp
          act: req
          inst_name: peri
          width: 1
          default: ""
          domain: Main
          top_signame: adc_ctrl_tl
          index: -1
          external: true
          conn_type: false
        }
        {
          name: tl_ast
          struct: tl
          package: tlul_pkg
          type: req_rsp
          act: req
          inst_name: peri
          width: 1
          default: ""
          domain: Main
          top_signame: ast_tl
          index: -1
        }
      ]
    }
  ]
  pinout:
  {
    banks:
    [
      VCC
      AVCC
      VIOA
      VIOB
    ]
    pads:
    [
      {
        name: POR_N
        type: InputStd
        bank: VCC
        connection: manual
        desc: System reset based on VCC
        idx: 0
        port_type: inout
      }
      {
        name: PORA_N
        type: InputStd
        bank: VIOA
        connection: manual
        desc: System reset based on VIOA
        idx: 1
        port_type: inout
      }
      {
        name: USB_P
        type: DualBidirTol
        bank: VCC
        connection: manual
        desc: USB P signal
        idx: 2
        port_type: inout
      }
      {
        name: USB_N
        type: DualBidirTol
        bank: VCC
        connection: manual
        desc: USB N signal
        idx: 3
        port_type: inout
      }
      {
        name: CC1
        type: BidirTol
        bank: AVCC
        connection: manual
        desc: ADC input 1
        port_type: `INOUT_AI
        idx: 4
      }
      {
        name: CC2
        type: BidirTol
        bank: AVCC
        connection: manual
        desc: ADC input 2
        port_type: `INOUT_AI
        idx: 5
      }
      {
        name: RRAM_ANALOG
        type: AnalogIn0
        bank: VCC
        connection: manual
        desc: RRAM analog test signal
        idx: 6
        port_type: inout
      }
      {
        name: SPI_HOST_D0
        type: BidirStr
        bank: VIOA
        connection: direct
        desc: SPI host data
        idx: 7
        port_type: inout
      }
      {
        name: SPI_HOST_D1
        type: BidirStr
        bank: VIOA
        connection: direct
        desc: SPI host data
        idx: 8
        port_type: inout
      }
      {
        name: SPI_HOST_D2
        type: BidirStr
        bank: VIOA
        connection: direct
        desc: SPI host data
        idx: 9
        port_type: inout
      }
      {
        name: SPI_HOST_D3
        type: BidirStr
        bank: VIOA
        connection: direct
        desc: SPI host data
        idx: 10
        port_type: inout
      }
      {
        name: SPI_HOST_CLK
        type: BidirStr
        bank: VIOA
        connection: direct
        desc: SPI host clock
        idx: 11
        port_type: inout
      }
      {
        name: SPI_HOST_CS_L
        type: BidirStr
        bank: VIOA
        connection: direct
        desc: SPI host chip select
        idx: 12
        port_type: inout
      }
      {
        name: SPI_DEV_D0
        type: BidirStr
        bank: VIOA
        connection: direct
        desc: SPI device data
        idx: 13
        port_type: inout
      }
      {
        name: SPI_DEV_D1
        type: BidirStr
        bank: VIOA
        connection: direct
        desc: SPI device data
        idx: 14
        port_type: inout
      }
      {
        name: SPI_DEV_D2
        type: BidirStr
        bank: VIOA
        connection: direct
        desc: SPI device data
        idx: 15
        port_type: inout
      }
      {
        name: SPI_DEV_D3
        type: BidirStr
        bank: VIOA
        connection: direct
        desc: SPI device data
        idx: 16
        port_type: inout
      }
      {
        name: SPI_DEV_CLK
        type: InputStd
        bank: VIOA
        connection: direct
        desc: SPI device clock
        idx: 17
        port_type: inout
      }
      {
        name: SPI_DEV_CS_L
        type: InputStd
        bank: VIOA
        connection: direct
        desc: SPI device chip select
        idx: 18
        port_type: inout
      }
      {
        name: IOA0
        type: BidirStd
        bank: VIOA
        connection: muxed
        desc: Muxed IO pad
        idx: 0
        port_type: inout
      }
      {
        name: IOA1
        type: BidirStd
        bank: VIOA
        connection: muxed
        desc: Muxed IO pad
        idx: 1
        port_type: inout
      }
      {
        name: IOA2
        type: BidirStd
        bank: VIOA
        connection: muxed
        desc: Muxed IO pad
        port_type: `INOUT_AO
        idx: 2
      }
      {
        name: IOA3
        type: BidirStd
        bank: VIOA
        connection: muxed
        desc: Muxed IO pad
        port_type: `INOUT_AO
        idx: 3
      }
      {
        name: IOA4
        type: BidirStd
        bank: VIOA
        connection: muxed
        desc: Muxed IO pad
        idx: 4
        port_type: inout
      }
      {
        name: IOA5
        type: BidirStd
        bank: VIOA
        connection: muxed
        desc: Muxed IO pad
        idx: 5
        port_type: inout
      }
      {
        name: IOA6
        type: BidirStd
        bank: VIOA
        connection: muxed
        desc: Muxed IO pad
        idx: 6
        port_type: inout
      }
      {
        name: IOA7
        type: BidirStr
        bank: VIOA
        connection: muxed
        desc: Muxed IO pad
        idx: 7
        port_type: inout
      }
      {
        name: IOA8
        type: BidirStr
        bank: VIOA
        connection: muxed
        desc: Muxed IO pad
        idx: 8
        port_type: inout
      }
      {
        name: IOB0
        type: BidirStr
        bank: VIOB
        connection: muxed
        desc: Muxed IO pad
        idx: 9
        port_type: inout
      }
      {
        name: IOB1
        type: BidirStr
        bank: VIOB
        connection: muxed
        desc: Muxed IO pad
        idx: 10
        port_type: inout
      }
      {
        name: IOB2
        type: BidirStr
        bank: VIOB
        connection: muxed
        desc: Muxed IO pad
        idx: 11
        port_type: inout
      }
      {
        name: IOB3
        type: BidirStr
        bank: VIOB
        connection: muxed
        desc: Muxed IO pad
        idx: 12
        port_type: inout
      }
      {
        name: IOB4
        type: BidirStr
        bank: VIOB
        connection: muxed
        desc: Muxed IO pad
        idx: 13
        port_type: inout
      }
      {
        name: IOB5
        type: BidirStr
        bank: VIOB
        connection: muxed
        desc: Muxed IO pad
        idx: 14
        port_type: inout
      }
      {
        name: IOB6
        type: BidirStr
        bank: VIOB
        connection: muxed
        desc: Muxed IO pad
        idx: 15
        port_type: inout
      }
      {
        name: IOB7
        type: BidirStd
        bank: VIOB
        connection: muxed
        desc: Muxed IO pad
        idx: 16
        port_type: inout
      }
      {
        name: IOB8
        type: BidirStd
        bank: VIOB
        connection: muxed
        desc: Muxed IO pad
        idx: 17
        port_type: inout
      }
      {
        name: IOB9
        type: BidirStr
        bank: VIOB
        connection: muxed
        desc: Muxed IO pad
        idx: 18
        port_type: inout
      }
      {
        name: IOB10
        type: BidirStr
        bank: VIOB
        connection: muxed
        desc: Muxed IO pad
        idx: 19
        port_type: inout
      }
      {
        name: IOB11
        type: BidirStr
        bank: VIOB
        connection: muxed
        desc: Muxed IO pad
        idx: 20
        port_type: inout
      }
      {
        name: IOB12
        type: BidirStr
        bank: VIOB
        connection: muxed
        desc: Muxed IO pad
        idx: 21
        port_type: inout
      }
      {
        name: IOC0
        type: BidirStd
        bank: VCC
        connection: muxed
        desc: Muxed IO pad
        idx: 22
        port_type: inout
      }
      {
        name: IOC1
        type: BidirStd
        bank: VCC
        connection: muxed
        desc: Muxed IO pad
        idx: 23
        port_type: inout
      }
      {
        name: IOC2
        type: BidirStd
        bank: VCC
        connection: muxed
        desc: Muxed IO pad
        idx: 24
        port_type: inout
      }
      {
        name: IOC3
        type: BidirStd
        bank: VCC
        connection: muxed
        desc: Muxed IO pad
        idx: 25
        port_type: inout
      }
      {
        name: IOC4
        type: BidirStd
        bank: VCC
        connection: muxed
        desc: Muxed IO pad
        idx: 26
        port_type: inout
      }
      {
        name: IOC5
        type: BidirStd
        bank: VCC
        connection: muxed
        desc: Muxed IO pad
        idx: 27
        port_type: inout
      }
      {
        name: IOC6
        type: BidirStd
        bank: VCC
        connection: muxed
        desc: Muxed IO pad
        idx: 28
        port_type: inout
      }
      {
        name: IOC7
        type: BidirStd
        bank: VCC
        connection: muxed
        desc: Muxed IO pad
        idx: 29
        port_type: inout
      }
      {
        name: IOC8
        type: BidirStd
        bank: VCC
        connection: muxed
        desc: Muxed IO pad
        attrs:
        {
          pull_en: 1
        }
        idx: 30
        port_type: inout
      }
      {
        name: IOC9
        type: BidirStd
        bank: VCC
        connection: muxed
        desc: Muxed IO pad
        idx: 31
        port_type: inout
      }
      {
        name: IOC10
        type: BidirStd
        bank: VCC
        connection: muxed
        desc: Muxed IO pad
        idx: 32
        port_type: inout
      }
      {
        name: IOC11
        type: BidirStd
        bank: VCC
        connection: muxed
        desc: Muxed IO pad
        idx: 33
        port_type: inout
      }
      {
        name: IOC12
        type: BidirStd
        bank: VCC
        connection: muxed
        desc: Muxed IO pad
        idx: 34
        port_type: inout
      }
      {
        name: IOR0
        type: BidirStd
        bank: VCC
        connection: muxed
        desc: Muxed IO pad
        idx: 35
        port_type: inout
      }
      {
        name: IOR1
        type: BidirStd
        bank: VCC
        connection: muxed
        desc: Muxed IO pad
        idx: 36
        port_type: inout
      }
      {
        name: IOR2
        type: BidirStd
        bank: VCC
        connection: muxed
        desc: Muxed IO pad
        idx: 37
        port_type: inout
      }
      {
        name: IOR3
        type: BidirStd
        bank: VCC
        connection: muxed
        desc: Muxed IO pad
        idx: 38
        port_type: inout
      }
      {
        name: IOR4
        type: BidirStd
        bank: VCC
        connection: muxed
        desc: Muxed IO pad
        idx: 39
        port_type: inout
      }
      {
        name: IOR5
        type: BidirStd
        bank: VCC
        connection: muxed
        desc: Muxed IO pad
        idx: 40
        port_type: inout
      }
      {
        name: IOR6
        type: BidirStd
        bank: VCC
        connection: muxed
        desc: Muxed IO pad
        idx: 41
        port_type: inout
      }
      {
        name: IOR7
        type: BidirStd
        bank: VCC
        connection: muxed
        desc: Muxed IO pad
        idx: 42
        port_type: inout
      }
      {
        name: IOR8
        type: BidirStd
        bank: VCC
        connection: direct
        desc: Dedicated sysrst_ctrl output (ec_rst_l)
        attrs:
        {
          virtual_od_en: 1
        }
        idx: 19
        port_type: inout
      }
      {
        name: IOR9
        type: BidirStd
        bank: VCC
        connection: direct
        desc: Dedicated sysrst_ctrl output (flash_wp_l))
        attrs:
        {
          virtual_od_en: 1
        }
        idx: 20
        port_type: inout
      }
      {
        name: IOR10
        type: BidirStd
        bank: VCC
        connection: muxed
        desc: Muxed IO pad
        idx: 43
        port_type: inout
      }
      {
        name: IOR11
        type: BidirStd
        bank: VCC
        connection: muxed
        desc: Muxed IO pad
        idx: 44
        port_type: inout
      }
      {
        name: IOR12
        type: BidirStd
        bank: VCC
        connection: muxed
        desc: Muxed IO pad
        idx: 45
        port_type: inout
      }
      {
        name: IOR13
        type: BidirStd
        bank: VCC
        connection: muxed
        desc: Muxed IO pad
        idx: 46
        port_type: inout
      }
    ]
  }
  pinmux:
  {
    signals:
    [
      {
        instance: usbdev
        port: usb_dp
        connection: manual
        pads: []
        desc: ""
        attr: BidirStd
      }
      {
        instance: usbdev
        port: usb_dn
        connection: manual
        pads: []
        desc: ""
        attr: BidirStd
      }
      {
        instance: spi_host0
        port: sck
        connection: direct
        pads:
        [
          SPI_HOST_CLK
        ]
        desc: ""
        attr: BidirStr
      }
      {
        instance: spi_host0
        port: csb[0]
        connection: direct
        pads:
        [
          SPI_HOST_CS_L
        ]
        desc: ""
        attr: BidirStr
      }
      {
        instance: spi_host0
        port: sd[0]
        connection: direct
        pads:
        [
          SPI_HOST_D0
        ]
        desc: ""
        attr: BidirStr
      }
      {
        instance: spi_host0
        port: sd[1]
        connection: direct
        pads:
        [
          SPI_HOST_D1
        ]
        desc: ""
        attr: BidirStr
      }
      {
        instance: spi_host0
        port: sd[2]
        connection: direct
        pads:
        [
          SPI_HOST_D2
        ]
        desc: ""
        attr: BidirStr
      }
      {
        instance: spi_host0
        port: sd[3]
        connection: direct
        pads:
        [
          SPI_HOST_D3
        ]
        desc: ""
        attr: BidirStr
      }
      {
        instance: spi_device
        port: sck
        connection: direct
        pads:
        [
          SPI_DEV_CLK
        ]
        desc: ""
        attr: InputStd
      }
      {
        instance: spi_device
        port: csb
        connection: direct
        pads:
        [
          SPI_DEV_CS_L
        ]
        desc: ""
        attr: InputStd
      }
      {
        instance: spi_device
        port: sd[0]
        connection: direct
        pads:
        [
          SPI_DEV_D0
        ]
        desc: ""
        attr: BidirStr
      }
      {
        instance: spi_device
        port: sd[1]
        connection: direct
        pads:
        [
          SPI_DEV_D1
        ]
        desc: ""
        attr: BidirStr
      }
      {
        instance: spi_device
        port: sd[2]
        connection: direct
        pads:
        [
          SPI_DEV_D2
        ]
        desc: ""
        attr: BidirStr
      }
      {
        instance: spi_device
        port: sd[3]
        connection: direct
        pads:
        [
          SPI_DEV_D3
        ]
        desc: ""
        attr: BidirStr
      }
      {
        instance: gpio0
        port: gpio[0]
        connection: muxed
        pads: []
        desc: ""
        attr: ""
      }
      {
        instance: gpio0
        port: gpio[1]
        connection: muxed
        pads: []
        desc: ""
        attr: ""
      }
      {
        instance: gpio0
        port: gpio[2]
        connection: muxed
        pads: []
        desc: ""
        attr: ""
      }
      {
        instance: gpio0
        port: gpio[3]
        connection: muxed
        pads: []
        desc: ""
        attr: ""
      }
      {
        instance: gpio0
        port: gpio[4]
        connection: muxed
        pads: []
        desc: ""
        attr: ""
      }
      {
        instance: gpio0
        port: gpio[5]
        connection: muxed
        pads: []
        desc: ""
        attr: ""
      }
      {
        instance: gpio0
        port: gpio[6]
        connection: muxed
        pads: []
        desc: ""
        attr: ""
      }
      {
        instance: gpio0
        port: gpio[7]
        connection: muxed
        pads: []
        desc: ""
        attr: ""
      }
      {
        instance: gpio0
        port: gpio[8]
        connection: muxed
        pads: []
        desc: ""
        attr: ""
      }
      {
        instance: gpio0
        port: gpio[9]
        connection: muxed
        pads: []
        desc: ""
        attr: ""
      }
      {
        instance: gpio0
        port: gpio[10]
        connection: muxed
        pads: []
        desc: ""
        attr: ""
      }
      {
        instance: gpio0
        port: gpio[11]
        connection: muxed
        pads: []
        desc: ""
        attr: ""
      }
      {
        instance: gpio0
        port: gpio[12]
        connection: muxed
        pads: []
        desc: ""
        attr: ""
      }
      {
        instance: gpio0
        port: gpio[13]
        connection: muxed
        pads: []
        desc: ""
        attr: ""
      }
      {
        instance: gpio0
        port: gpio[14]
        connection: muxed
        pads: []
        desc: ""
        attr: ""
      }
      {
        instance: gpio0
        port: gpio[15]
        connection: muxed
        pads: []
        desc: ""
        attr: ""
      }
      {
        instance: gpio0
        port: gpio[16]
        connection: muxed
        pads: []
        desc: ""
        attr: ""
      }
      {
        instance: gpio0
        port: gpio[17]
        connection: muxed
        pads: []
        desc: ""
        attr: ""
      }
      {
        instance: gpio0
        port: gpio[18]
        connection: muxed
        pads: []
        desc: ""
        attr: ""
      }
      {
        instance: gpio0
        port: gpio[19]
        connection: muxed
        pads: []
        desc: ""
        attr: ""
      }
      {
        instance: gpio0
        port: gpio[20]
        connection: muxed
        pads: []
        desc: ""
        attr: ""
      }
      {
        instance: gpio0
        port: gpio[21]
        connection: muxed
        pads: []
        desc: ""
        attr: ""
      }
      {
        instance: gpio0
        port: gpio[22]
        connection: muxed
        pads: []
        desc: ""
        attr: ""
      }
      {
        instance: gpio0
        port: gpio[23]
        connection: muxed
        pads: []
        desc: ""
        attr: ""
      }
      {
        instance: gpio0
        port: gpio[24]
        connection: muxed
        pads: []
        desc: ""
        attr: ""
      }
      {
        instance: gpio0
        port: gpio[25]
        connection: muxed
        pads: []
        desc: ""
        attr: ""
      }
      {
        instance: gpio0
        port: gpio[26]
        connection: muxed
        pads: []
        desc: ""
        attr: ""
      }
      {
        instance: gpio0
        port: gpio[27]
        connection: muxed
        pads: []
        desc: ""
        attr: ""
      }
      {
        instance: gpio0
        port: gpio[28]
        connection: muxed
        pads: []
        desc: ""
        attr: ""
      }
      {
        instance: gpio0
        port: gpio[29]
        connection: muxed
        pads: []
        desc: ""
        attr: ""
      }
      {
        instance: gpio0
        port: gpio[30]
        connection: muxed
        pads: []
        desc: ""
        attr: ""
      }
      {
        instance: gpio0
        port: gpio[31]
        connection: muxed
        pads: []
        desc: ""
        attr: ""
      }
      {
        instance: gpio1
        port: gpio[0]
        connection: muxed
        pads: []
        desc: ""
        attr: ""
      }
      {
        instance: gpio1
        port: gpio[1]
        connection: muxed
        pads: []
        desc: ""
        attr: ""
      }
      {
        instance: gpio1
        port: gpio[2]
        connection: muxed
        pads: []
        desc: ""
        attr: ""
      }
      {
        instance: gpio1
        port: gpio[3]
        connection: muxed
        pads: []
        desc: ""
        attr: ""
      }
      {
        instance: gpio1
        port: gpio[4]
        connection: muxed
        pads: []
        desc: ""
        attr: ""
      }
      {
        instance: gpio1
        port: gpio[5]
        connection: muxed
        pads: []
        desc: ""
        attr: ""
      }
      {
        instance: gpio1
        port: gpio[6]
        connection: muxed
        pads: []
        desc: ""
        attr: ""
      }
      {
        instance: gpio1
        port: gpio[7]
        connection: muxed
        pads: []
        desc: ""
        attr: ""
      }
      {
        instance: gpio1
        port: gpio[8]
        connection: muxed
        pads: []
        desc: ""
        attr: ""
      }
      {
        instance: gpio1
        port: gpio[9]
        connection: muxed
        pads: []
        desc: ""
        attr: ""
      }
      {
        instance: gpio1
        port: gpio[10]
        connection: muxed
        pads: []
        desc: ""
        attr: ""
      }
      {
        instance: gpio1
        port: gpio[11]
        connection: muxed
        pads: []
        desc: ""
        attr: ""
      }
      {
        instance: gpio1
        port: gpio[12]
        connection: muxed
        pads: []
        desc: ""
        attr: ""
      }
      {
        instance: gpio1
        port: gpio[13]
        connection: muxed
        pads: []
        desc: ""
        attr: ""
      }
      {
        instance: gpio1
        port: gpio[14]
        connection: muxed
        pads: []
        desc: ""
        attr: ""
      }
      {
        instance: gpio1
        port: gpio[15]
        connection: muxed
        pads: []
        desc: ""
        attr: ""
      }
      {
        instance: gpio1
        port: gpio[16]
        connection: muxed
        pads: []
        desc: ""
        attr: ""
      }
      {
        instance: gpio1
        port: gpio[17]
        connection: muxed
        pads: []
        desc: ""
        attr: ""
      }
      {
        instance: gpio1
        port: gpio[18]
        connection: muxed
        pads: []
        desc: ""
        attr: ""
      }
      {
        instance: gpio1
        port: gpio[19]
        connection: muxed
        pads: []
        desc: ""
        attr: ""
      }
      {
        instance: gpio1
        port: gpio[20]
        connection: muxed
        pads: []
        desc: ""
        attr: ""
      }
      {
        instance: gpio1
        port: gpio[21]
        connection: muxed
        pads: []
        desc: ""
        attr: ""
      }
      {
        instance: gpio1
        port: gpio[22]
        connection: muxed
        pads: []
        desc: ""
        attr: ""
      }
      {
        instance: gpio1
        port: gpio[23]
        connection: muxed
        pads: []
        desc: ""
        attr: ""
      }
      {
        instance: gpio1
        port: gpio[24]
        connection: muxed
        pads: []
        desc: ""
        attr: ""
      }
      {
        instance: gpio1
        port: gpio[25]
        connection: muxed
        pads: []
        desc: ""
        attr: ""
      }
      {
        instance: gpio1
        port: gpio[26]
        connection: muxed
        pads: []
        desc: ""
        attr: ""
      }
      {
        instance: gpio1
        port: gpio[27]
        connection: muxed
        pads: []
        desc: ""
        attr: ""
      }
      {
        instance: gpio1
        port: gpio[28]
        connection: muxed
        pads: []
        desc: ""
        attr: ""
      }
      {
        instance: gpio1
        port: gpio[29]
        connection: muxed
        pads: []
        desc: ""
        attr: ""
      }
      {
        instance: gpio1
        port: gpio[30]
        connection: muxed
        pads: []
        desc: ""
        attr: ""
      }
      {
        instance: gpio1
        port: gpio[31]
        connection: muxed
        pads: []
        desc: ""
        attr: ""
      }
      {
        instance: uart0
        port: rx
        connection: muxed
        pads: []
        desc: ""
        attr: ""
      }
      {
        instance: uart0
        port: tx
        connection: muxed
        pads: []
        desc: ""
        attr: ""
      }
      {
        instance: uart1
        port: rx
        connection: muxed
        pads: []
        desc: ""
        attr: ""
      }
      {
        instance: uart1
        port: tx
        connection: muxed
        pads: []
        desc: ""
        attr: ""
      }
      {
        instance: uart2
        port: rx
        connection: muxed
        pads: []
        desc: ""
        attr: ""
      }
      {
        instance: uart2
        port: tx
        connection: muxed
        pads: []
        desc: ""
        attr: ""
      }
      {
        instance: uart3
        port: rx
        connection: muxed
        pads: []
        desc: ""
        attr: ""
      }
      {
        instance: uart3
        port: tx
        connection: muxed
        pads: []
        desc: ""
        attr: ""
      }
      {
        instance: i2c0
        port: sda
        connection: muxed
        pads: []
        desc: ""
        attr: ""
      }
      {
        instance: i2c0
        port: scl
        connection: muxed
        pads: []
        desc: ""
        attr: ""
      }
      {
        instance: i2c1
        port: sda
        connection: muxed
        pads: []
        desc: ""
        attr: ""
      }
      {
        instance: i2c1
        port: scl
        connection: muxed
        pads: []
        desc: ""
        attr: ""
      }
      {
        instance: i2c2
        port: sda
        connection: muxed
        pads: []
        desc: ""
        attr: ""
      }
      {
        instance: i2c2
        port: scl
        connection: muxed
        pads: []
        desc: ""
        attr: ""
      }
      {
        instance: i3c0
        port: scl
        connection: muxed
        pads: []
        desc: ""
        attr: ""
      }
      {
        instance: i3c0
        port: sda
        connection: muxed
        pads: []
        desc: ""
        attr: ""
      }
      {
        instance: i3c0
        port: ctrl_sda_pu
        connection: muxed
        pads: []
        desc: ""
        attr: ""
      }
      {
        instance: i3c0
        port: rstdet_scl
        connection: muxed
        pads: []
        desc: ""
        attr: ""
      }
      {
        instance: i3c0
        port: rstdet_sda
        connection: muxed
        pads: []
        desc: ""
        attr: ""
      }
      {
        instance: i3c1
        port: scl
        connection: muxed
        pads: []
        desc: ""
        attr: ""
      }
      {
        instance: i3c1
        port: sda
        connection: muxed
        pads: []
        desc: ""
        attr: ""
      }
      {
        instance: i3c1
        port: ctrl_sda_pu
        connection: muxed
        pads: []
        desc: ""
        attr: ""
      }
      {
        instance: i3c1
        port: rstdet_scl
        connection: muxed
        pads: []
        desc: ""
        attr: ""
      }
      {
        instance: i3c1
        port: rstdet_sda
        connection: muxed
        pads: []
        desc: ""
        attr: ""
      }
      {
        instance: spi_device
        port: tpm_csb
        connection: muxed
        pads: []
        desc: ""
        attr: ""
      }
      {
        instance: spi_host0
        port: csb[1]
        connection: muxed
        pads: []
        desc: ""
        attr: ""
      }
      {
        instance: spi_host0
        port: csb[2]
        connection: muxed
        pads: []
        desc: ""
        attr: ""
      }
      {
        instance: spi_host1
        port: sck
        connection: muxed
        pads: []
        desc: ""
        attr: ""
      }
      {
        instance: spi_host1
        port: csb[0]
        connection: muxed
        pads: []
        desc: ""
        attr: ""
      }
      {
        instance: spi_host1
        port: csb[1]
        connection: muxed
        pads: []
        desc: ""
        attr: ""
      }
      {
        instance: spi_host1
        port: csb[2]
        connection: muxed
        pads: []
        desc: ""
        attr: ""
      }
      {
        instance: spi_host1
        port: sd[0]
        connection: muxed
        pads: []
        desc: ""
        attr: ""
      }
      {
        instance: spi_host1
        port: sd[1]
        connection: muxed
        pads: []
        desc: ""
        attr: ""
      }
      {
        instance: spi_host1
        port: sd[2]
        connection: muxed
        pads: []
        desc: ""
        attr: ""
      }
      {
        instance: spi_host1
        port: sd[3]
        connection: muxed
        pads: []
        desc: ""
        attr: ""
      }
      {
        instance: sensor_ctrl
        port: ast_debug_out[0]
        connection: muxed
        pads: []
        desc: ""
        attr: ""
      }
      {
        instance: sensor_ctrl
        port: ast_debug_out[1]
        connection: muxed
        pads: []
        desc: ""
        attr: ""
      }
      {
        instance: sensor_ctrl
        port: ast_debug_out[2]
        connection: muxed
        pads: []
        desc: ""
        attr: ""
      }
      {
        instance: sensor_ctrl
        port: ast_debug_out[3]
        connection: muxed
        pads: []
        desc: ""
        attr: ""
      }
      {
        instance: sensor_ctrl
        port: ast_debug_out[4]
        connection: muxed
        pads: []
        desc: ""
        attr: ""
      }
      {
        instance: sensor_ctrl
        port: ast_debug_out[5]
        connection: muxed
        pads: []
        desc: ""
        attr: ""
      }
      {
        instance: sensor_ctrl
        port: ast_debug_out[6]
        connection: muxed
        pads: []
        desc: ""
        attr: ""
      }
      {
        instance: sensor_ctrl
        port: ast_debug_out[7]
        connection: muxed
        pads: []
        desc: ""
        attr: ""
      }
      {
        instance: sensor_ctrl
        port: ast_debug_out[8]
        connection: muxed
        pads: []
        desc: ""
        attr: ""
      }
      {
        instance: sysrst_ctrl
        port: ac_present
        connection: muxed
        pads: []
        desc: ""
        attr: ""
      }
      {
        instance: sysrst_ctrl
        port: key0_in
        connection: muxed
        pads: []
        desc: ""
        attr: ""
      }
      {
        instance: sysrst_ctrl
        port: key1_in
        connection: muxed
        pads: []
        desc: ""
        attr: ""
      }
      {
        instance: sysrst_ctrl
        port: key2_in
        connection: muxed
        pads: []
        desc: ""
        attr: ""
      }
      {
        instance: sysrst_ctrl
        port: pwrb_in
        connection: muxed
        pads: []
        desc: ""
        attr: ""
      }
      {
        instance: sysrst_ctrl
        port: bat_disable
        connection: muxed
        pads: []
        desc: ""
        attr: ""
      }
      {
        instance: sysrst_ctrl
        port: ec_rst_l
        connection: direct
        pads:
        [
          IOR8
        ]
        desc: ""
        attr: BidirStd
      }
      {
        instance: sysrst_ctrl
        port: flash_wp_l
        connection: direct
        pads:
        [
          IOR9
        ]
        desc: ""
        attr: BidirStd
      }
      {
        instance: sysrst_ctrl
        port: key0_out
        connection: muxed
        pads: []
        desc: ""
        attr: ""
      }
      {
        instance: sysrst_ctrl
        port: key1_out
        connection: muxed
        pads: []
        desc: ""
        attr: ""
      }
      {
        instance: sysrst_ctrl
        port: key2_out
        connection: muxed
        pads: []
        desc: ""
        attr: ""
      }
      {
        instance: sysrst_ctrl
        port: pwrb_out
        connection: muxed
        pads: []
        desc: ""
        attr: ""
      }
      {
        instance: sysrst_ctrl
        port: lid_open
        connection: muxed
        pads: []
        desc: ""
        attr: ""
      }
      {
        instance: sysrst_ctrl
        port: z3_wakeup
        connection: muxed
        pads: []
        desc: ""
        attr: ""
      }
      {
        instance: usbdev
        port: sense
        connection: muxed
        pads: []
        desc: ""
        attr: ""
      }
    ]
    num_wkup_detect: 8
    wkup_cnt_width: 8
    enable_usb_wakeup: true
    enable_strap_sampling: true
    enable_rram_tap: true
    ios:
    [
      {
        name: usbdev_usb_dp
        width: 1
        type: inout
        idx: -1
        pads: []
        attr: BidirStd
        connection: manual
        desc: ""
        domain: Main
        glob_idx: 0
      }
      {
        name: usbdev_usb_dn
        width: 1
        type: inout
        idx: -1
        pads: []
        attr: BidirStd
        connection: manual
        desc: ""
        domain: Main
        glob_idx: 1
      }
      {
        name: spi_host0_sd
        width: 4
        type: inout
        idx: 0
        pads:
        [
          SPI_HOST_D0
        ]
        attr: BidirStr
        connection: direct
        desc: ""
        domain: Main
        glob_idx: 2
      }
      {
        name: spi_host0_sd
        width: 4
        type: inout
        idx: 1
        pads:
        [
          SPI_HOST_D1
        ]
        attr: BidirStr
        connection: direct
        desc: ""
        domain: Main
        glob_idx: 3
      }
      {
        name: spi_host0_sd
        width: 4
        type: inout
        idx: 2
        pads:
        [
          SPI_HOST_D2
        ]
        attr: BidirStr
        connection: direct
        desc: ""
        domain: Main
        glob_idx: 4
      }
      {
        name: spi_host0_sd
        width: 4
        type: inout
        idx: 3
        pads:
        [
          SPI_HOST_D3
        ]
        attr: BidirStr
        connection: direct
        desc: ""
        domain: Main
        glob_idx: 5
      }
      {
        name: spi_device_sd
        width: 4
        type: inout
        idx: 0
        pads:
        [
          SPI_DEV_D0
        ]
        attr: BidirStr
        connection: direct
        desc: ""
        domain: Main
        glob_idx: 6
      }
      {
        name: spi_device_sd
        width: 4
        type: inout
        idx: 1
        pads:
        [
          SPI_DEV_D1
        ]
        attr: BidirStr
        connection: direct
        desc: ""
        domain: Main
        glob_idx: 7
      }
      {
        name: spi_device_sd
        width: 4
        type: inout
        idx: 2
        pads:
        [
          SPI_DEV_D2
        ]
        attr: BidirStr
        connection: direct
        desc: ""
        domain: Main
        glob_idx: 8
      }
      {
        name: spi_device_sd
        width: 4
        type: inout
        idx: 3
        pads:
        [
          SPI_DEV_D3
        ]
        attr: BidirStr
        connection: direct
        desc: ""
        domain: Main
        glob_idx: 9
      }
      {
        name: gpio0_gpio
        width: 32
        type: inout
        idx: 0
        pads: []
        attr: ""
        connection: muxed
        desc: ""
        domain: Main
        glob_idx: 0
      }
      {
        name: gpio0_gpio
        width: 32
        type: inout
        idx: 1
        pads: []
        attr: ""
        connection: muxed
        desc: ""
        domain: Main
        glob_idx: 1
      }
      {
        name: gpio0_gpio
        width: 32
        type: inout
        idx: 2
        pads: []
        attr: ""
        connection: muxed
        desc: ""
        domain: Main
        glob_idx: 2
      }
      {
        name: gpio0_gpio
        width: 32
        type: inout
        idx: 3
        pads: []
        attr: ""
        connection: muxed
        desc: ""
        domain: Main
        glob_idx: 3
      }
      {
        name: gpio0_gpio
        width: 32
        type: inout
        idx: 4
        pads: []
        attr: ""
        connection: muxed
        desc: ""
        domain: Main
        glob_idx: 4
      }
      {
        name: gpio0_gpio
        width: 32
        type: inout
        idx: 5
        pads: []
        attr: ""
        connection: muxed
        desc: ""
        domain: Main
        glob_idx: 5
      }
      {
        name: gpio0_gpio
        width: 32
        type: inout
        idx: 6
        pads: []
        attr: ""
        connection: muxed
        desc: ""
        domain: Main
        glob_idx: 6
      }
      {
        name: gpio0_gpio
        width: 32
        type: inout
        idx: 7
        pads: []
        attr: ""
        connection: muxed
        desc: ""
        domain: Main
        glob_idx: 7
      }
      {
        name: gpio0_gpio
        width: 32
        type: inout
        idx: 8
        pads: []
        attr: ""
        connection: muxed
        desc: ""
        domain: Main
        glob_idx: 8
      }
      {
        name: gpio0_gpio
        width: 32
        type: inout
        idx: 9
        pads: []
        attr: ""
        connection: muxed
        desc: ""
        domain: Main
        glob_idx: 9
      }
      {
        name: gpio0_gpio
        width: 32
        type: inout
        idx: 10
        pads: []
        attr: ""
        connection: muxed
        desc: ""
        domain: Main
        glob_idx: 10
      }
      {
        name: gpio0_gpio
        width: 32
        type: inout
        idx: 11
        pads: []
        attr: ""
        connection: muxed
        desc: ""
        domain: Main
        glob_idx: 11
      }
      {
        name: gpio0_gpio
        width: 32
        type: inout
        idx: 12
        pads: []
        attr: ""
        connection: muxed
        desc: ""
        domain: Main
        glob_idx: 12
      }
      {
        name: gpio0_gpio
        width: 32
        type: inout
        idx: 13
        pads: []
        attr: ""
        connection: muxed
        desc: ""
        domain: Main
        glob_idx: 13
      }
      {
        name: gpio0_gpio
        width: 32
        type: inout
        idx: 14
        pads: []
        attr: ""
        connection: muxed
        desc: ""
        domain: Main
        glob_idx: 14
      }
      {
        name: gpio0_gpio
        width: 32
        type: inout
        idx: 15
        pads: []
        attr: ""
        connection: muxed
        desc: ""
        domain: Main
        glob_idx: 15
      }
      {
        name: gpio0_gpio
        width: 32
        type: inout
        idx: 16
        pads: []
        attr: ""
        connection: muxed
        desc: ""
        domain: Main
        glob_idx: 16
      }
      {
        name: gpio0_gpio
        width: 32
        type: inout
        idx: 17
        pads: []
        attr: ""
        connection: muxed
        desc: ""
        domain: Main
        glob_idx: 17
      }
      {
        name: gpio0_gpio
        width: 32
        type: inout
        idx: 18
        pads: []
        attr: ""
        connection: muxed
        desc: ""
        domain: Main
        glob_idx: 18
      }
      {
        name: gpio0_gpio
        width: 32
        type: inout
        idx: 19
        pads: []
        attr: ""
        connection: muxed
        desc: ""
        domain: Main
        glob_idx: 19
      }
      {
        name: gpio0_gpio
        width: 32
        type: inout
        idx: 20
        pads: []
        attr: ""
        connection: muxed
        desc: ""
        domain: Main
        glob_idx: 20
      }
      {
        name: gpio0_gpio
        width: 32
        type: inout
        idx: 21
        pads: []
        attr: ""
        connection: muxed
        desc: ""
        domain: Main
        glob_idx: 21
      }
      {
        name: gpio0_gpio
        width: 32
        type: inout
        idx: 22
        pads: []
        attr: ""
        connection: muxed
        desc: ""
        domain: Main
        glob_idx: 22
      }
      {
        name: gpio0_gpio
        width: 32
        type: inout
        idx: 23
        pads: []
        attr: ""
        connection: muxed
        desc: ""
        domain: Main
        glob_idx: 23
      }
      {
        name: gpio0_gpio
        width: 32
        type: inout
        idx: 24
        pads: []
        attr: ""
        connection: muxed
        desc: ""
        domain: Main
        glob_idx: 24
      }
      {
        name: gpio0_gpio
        width: 32
        type: inout
        idx: 25
        pads: []
        attr: ""
        connection: muxed
        desc: ""
        domain: Main
        glob_idx: 25
      }
      {
        name: gpio0_gpio
        width: 32
        type: inout
        idx: 26
        pads: []
        attr: ""
        connection: muxed
        desc: ""
        domain: Main
        glob_idx: 26
      }
      {
        name: gpio0_gpio
        width: 32
        type: inout
        idx: 27
        pads: []
        attr: ""
        connection: muxed
        desc: ""
        domain: Main
        glob_idx: 27
      }
      {
        name: gpio0_gpio
        width: 32
        type: inout
        idx: 28
        pads: []
        attr: ""
        connection: muxed
        desc: ""
        domain: Main
        glob_idx: 28
      }
      {
        name: gpio0_gpio
        width: 32
        type: inout
        idx: 29
        pads: []
        attr: ""
        connection: muxed
        desc: ""
        domain: Main
        glob_idx: 29
      }
      {
        name: gpio0_gpio
        width: 32
        type: inout
        idx: 30
        pads: []
        attr: ""
        connection: muxed
        desc: ""
        domain: Main
        glob_idx: 30
      }
      {
        name: gpio0_gpio
        width: 32
        type: inout
        idx: 31
        pads: []
        attr: ""
        connection: muxed
        desc: ""
        domain: Main
        glob_idx: 31
      }
      {
        name: gpio1_gpio
        width: 32
        type: inout
        idx: 0
        pads: []
        attr: ""
        connection: muxed
        desc: ""
        domain: Main
        glob_idx: 32
      }
      {
        name: gpio1_gpio
        width: 32
        type: inout
        idx: 1
        pads: []
        attr: ""
        connection: muxed
        desc: ""
        domain: Main
        glob_idx: 33
      }
      {
        name: gpio1_gpio
        width: 32
        type: inout
        idx: 2
        pads: []
        attr: ""
        connection: muxed
        desc: ""
        domain: Main
        glob_idx: 34
      }
      {
        name: gpio1_gpio
        width: 32
        type: inout
        idx: 3
        pads: []
        attr: ""
        connection: muxed
        desc: ""
        domain: Main
        glob_idx: 35
      }
      {
        name: gpio1_gpio
        width: 32
        type: inout
        idx: 4
        pads: []
        attr: ""
        connection: muxed
        desc: ""
        domain: Main
        glob_idx: 36
      }
      {
        name: gpio1_gpio
        width: 32
        type: inout
        idx: 5
        pads: []
        attr: ""
        connection: muxed
        desc: ""
        domain: Main
        glob_idx: 37
      }
      {
        name: gpio1_gpio
        width: 32
        type: inout
        idx: 6
        pads: []
        attr: ""
        connection: muxed
        desc: ""
        domain: Main
        glob_idx: 38
      }
      {
        name: gpio1_gpio
        width: 32
        type: inout
        idx: 7
        pads: []
        attr: ""
        connection: muxed
        desc: ""
        domain: Main
        glob_idx: 39
      }
      {
        name: gpio1_gpio
        width: 32
        type: inout
        idx: 8
        pads: []
        attr: ""
        connection: muxed
        desc: ""
        domain: Main
        glob_idx: 40
      }
      {
        name: gpio1_gpio
        width: 32
        type: inout
        idx: 9
        pads: []
        attr: ""
        connection: muxed
        desc: ""
        domain: Main
        glob_idx: 41
      }
      {
        name: gpio1_gpio
        width: 32
        type: inout
        idx: 10
        pads: []
        attr: ""
        connection: muxed
        desc: ""
        domain: Main
        glob_idx: 42
      }
      {
        name: gpio1_gpio
        width: 32
        type: inout
        idx: 11
        pads: []
        attr: ""
        connection: muxed
        desc: ""
        domain: Main
        glob_idx: 43
      }
      {
        name: gpio1_gpio
        width: 32
        type: inout
        idx: 12
        pads: []
        attr: ""
        connection: muxed
        desc: ""
        domain: Main
        glob_idx: 44
      }
      {
        name: gpio1_gpio
        width: 32
        type: inout
        idx: 13
        pads: []
        attr: ""
        connection: muxed
        desc: ""
        domain: Main
        glob_idx: 45
      }
      {
        name: gpio1_gpio
        width: 32
        type: inout
        idx: 14
        pads: []
        attr: ""
        connection: muxed
        desc: ""
        domain: Main
        glob_idx: 46
      }
      {
        name: gpio1_gpio
        width: 32
        type: inout
        idx: 15
        pads: []
        attr: ""
        connection: muxed
        desc: ""
        domain: Main
        glob_idx: 47
      }
      {
        name: gpio1_gpio
        width: 32
        type: inout
        idx: 16
        pads: []
        attr: ""
        connection: muxed
        desc: ""
        domain: Main
        glob_idx: 48
      }
      {
        name: gpio1_gpio
        width: 32
        type: inout
        idx: 17
        pads: []
        attr: ""
        connection: muxed
        desc: ""
        domain: Main
        glob_idx: 49
      }
      {
        name: gpio1_gpio
        width: 32
        type: inout
        idx: 18
        pads: []
        attr: ""
        connection: muxed
        desc: ""
        domain: Main
        glob_idx: 50
      }
      {
        name: gpio1_gpio
        width: 32
        type: inout
        idx: 19
        pads: []
        attr: ""
        connection: muxed
        desc: ""
        domain: Main
        glob_idx: 51
      }
      {
        name: gpio1_gpio
        width: 32
        type: inout
        idx: 20
        pads: []
        attr: ""
        connection: muxed
        desc: ""
        domain: Main
        glob_idx: 52
      }
      {
        name: gpio1_gpio
        width: 32
        type: inout
        idx: 21
        pads: []
        attr: ""
        connection: muxed
        desc: ""
        domain: Main
        glob_idx: 53
      }
      {
        name: gpio1_gpio
        width: 32
        type: inout
        idx: 22
        pads: []
        attr: ""
        connection: muxed
        desc: ""
        domain: Main
        glob_idx: 54
      }
      {
        name: gpio1_gpio
        width: 32
        type: inout
        idx: 23
        pads: []
        attr: ""
        connection: muxed
        desc: ""
        domain: Main
        glob_idx: 55
      }
      {
        name: gpio1_gpio
        width: 32
        type: inout
        idx: 24
        pads: []
        attr: ""
        connection: muxed
        desc: ""
        domain: Main
        glob_idx: 56
      }
      {
        name: gpio1_gpio
        width: 32
        type: inout
        idx: 25
        pads: []
        attr: ""
        connection: muxed
        desc: ""
        domain: Main
        glob_idx: 57
      }
      {
        name: gpio1_gpio
        width: 32
        type: inout
        idx: 26
        pads: []
        attr: ""
        connection: muxed
        desc: ""
        domain: Main
        glob_idx: 58
      }
      {
        name: gpio1_gpio
        width: 32
        type: inout
        idx: 27
        pads: []
        attr: ""
        connection: muxed
        desc: ""
        domain: Main
        glob_idx: 59
      }
      {
        name: gpio1_gpio
        width: 32
        type: inout
        idx: 28
        pads: []
        attr: ""
        connection: muxed
        desc: ""
        domain: Main
        glob_idx: 60
      }
      {
        name: gpio1_gpio
        width: 32
        type: inout
        idx: 29
        pads: []
        attr: ""
        connection: muxed
        desc: ""
        domain: Main
        glob_idx: 61
      }
      {
        name: gpio1_gpio
        width: 32
        type: inout
        idx: 30
        pads: []
        attr: ""
        connection: muxed
        desc: ""
        domain: Main
        glob_idx: 62
      }
      {
        name: gpio1_gpio
        width: 32
        type: inout
        idx: 31
        pads: []
        attr: ""
        connection: muxed
        desc: ""
        domain: Main
        glob_idx: 63
      }
      {
        name: i2c0_sda
        width: 1
        type: inout
        idx: -1
        pads: []
        attr: ""
        connection: muxed
        desc: ""
        domain: Main
        glob_idx: 64
      }
      {
        name: i2c0_scl
        width: 1
        type: inout
        idx: -1
        pads: []
        attr: ""
        connection: muxed
        desc: ""
        domain: Main
        glob_idx: 65
      }
      {
        name: i2c1_sda
        width: 1
        type: inout
        idx: -1
        pads: []
        attr: ""
        connection: muxed
        desc: ""
        domain: Main
        glob_idx: 66
      }
      {
        name: i2c1_scl
        width: 1
        type: inout
        idx: -1
        pads: []
        attr: ""
        connection: muxed
        desc: ""
        domain: Main
        glob_idx: 67
      }
      {
        name: i2c2_sda
        width: 1
        type: inout
        idx: -1
        pads: []
        attr: ""
        connection: muxed
        desc: ""
        domain: Main
        glob_idx: 68
      }
      {
        name: i2c2_scl
        width: 1
        type: inout
        idx: -1
        pads: []
        attr: ""
        connection: muxed
        desc: ""
        domain: Main
        glob_idx: 69
      }
      {
        name: i3c0_scl
        width: 1
        type: inout
        idx: -1
        pads: []
        attr: ""
        connection: muxed
        desc: ""
        domain: Main
        glob_idx: 70
      }
      {
        name: i3c0_sda
        width: 1
        type: inout
        idx: -1
        pads: []
        attr: ""
        connection: muxed
        desc: ""
        domain: Main
        glob_idx: 71
      }
      {
        name: i3c1_scl
        width: 1
        type: inout
        idx: -1
        pads: []
        attr: ""
        connection: muxed
        desc: ""
        domain: Main
        glob_idx: 72
      }
      {
        name: i3c1_sda
        width: 1
        type: inout
        idx: -1
        pads: []
        attr: ""
        connection: muxed
        desc: ""
        domain: Main
        glob_idx: 73
      }
      {
        name: spi_host1_sd
        width: 4
        type: inout
        idx: 0
        pads: []
        attr: ""
        connection: muxed
        desc: ""
        domain: Main
        glob_idx: 74
      }
      {
        name: spi_host1_sd
        width: 4
        type: inout
        idx: 1
        pads: []
        attr: ""
        connection: muxed
        desc: ""
        domain: Main
        glob_idx: 75
      }
      {
        name: spi_host1_sd
        width: 4
        type: inout
        idx: 2
        pads: []
        attr: ""
        connection: muxed
        desc: ""
        domain: Main
        glob_idx: 76
      }
      {
        name: spi_host1_sd
        width: 4
        type: inout
        idx: 3
        pads: []
        attr: ""
        connection: muxed
        desc: ""
        domain: Main
        glob_idx: 77
      }
      {
        name: sysrst_ctrl_ec_rst_l
        width: 1
        type: inout
        idx: -1
        pads:
        [
          IOR8
        ]
        attr: BidirStd
        connection: direct
        desc: ""
        domain: Aon
        glob_idx: 10
      }
      {
        name: sysrst_ctrl_flash_wp_l
        width: 1
        type: inout
        idx: -1
        pads:
        [
          IOR9
        ]
        attr: BidirStd
        connection: direct
        desc: ""
        domain: Aon
        glob_idx: 11
      }
      {
        name: spi_device_sck
        width: 1
        type: input
        idx: -1
        pads:
        [
          SPI_DEV_CLK
        ]
        attr: InputStd
        connection: direct
        desc: ""
        domain: Main
        glob_idx: 12
      }
      {
        name: spi_device_csb
        width: 1
        type: input
        idx: -1
        pads:
        [
          SPI_DEV_CS_L
        ]
        attr: InputStd
        connection: direct
        desc: ""
        domain: Main
        glob_idx: 13
      }
      {
        name: uart0_rx
        width: 1
        type: input
        idx: -1
        pads: []
        attr: ""
        connection: muxed
        desc: ""
        domain: Main
        glob_idx: 78
      }
      {
        name: uart1_rx
        width: 1
        type: input
        idx: -1
        pads: []
        attr: ""
        connection: muxed
        desc: ""
        domain: Main
        glob_idx: 79
      }
      {
        name: uart2_rx
        width: 1
        type: input
        idx: -1
        pads: []
        attr: ""
        connection: muxed
        desc: ""
        domain: Main
        glob_idx: 80
      }
      {
        name: uart3_rx
        width: 1
        type: input
        idx: -1
        pads: []
        attr: ""
        connection: muxed
        desc: ""
        domain: Main
        glob_idx: 81
      }
      {
        name: i3c0_rstdet_scl
        width: 1
        type: input
        partition: secondary
        idx: -1
        pads: []
        attr: ""
        connection: muxed
        desc: ""
        domain: Aon
        glob_idx: 82
      }
      {
        name: i3c0_rstdet_sda
        width: 1
        type: input
        partition: secondary
        idx: -1
        pads: []
        attr: ""
        connection: muxed
        desc: ""
        domain: Aon
        glob_idx: 83
      }
      {
        name: i3c1_rstdet_scl
        width: 1
        type: input
        partition: secondary
        idx: -1
        pads: []
        attr: ""
        connection: muxed
        desc: ""
        domain: Main
        glob_idx: 84
      }
      {
        name: i3c1_rstdet_sda
        width: 1
        type: input
        partition: secondary
        idx: -1
        pads: []
        attr: ""
        connection: muxed
        desc: ""
        domain: Main
        glob_idx: 85
      }
      {
        name: spi_device_tpm_csb
        width: 1
        type: input
        idx: -1
        pads: []
        attr: ""
        connection: muxed
        desc: ""
        domain: Main
        glob_idx: 86
      }
      {
        name: sysrst_ctrl_ac_present
        width: 1
        type: input
        idx: -1
        pads: []
        attr: ""
        connection: muxed
        desc: ""
        domain: Aon
        glob_idx: 87
      }
      {
        name: sysrst_ctrl_key0_in
        width: 1
        type: input
        idx: -1
        pads: []
        attr: ""
        connection: muxed
        desc: ""
        domain: Aon
        glob_idx: 88
      }
      {
        name: sysrst_ctrl_key1_in
        width: 1
        type: input
        idx: -1
        pads: []
        attr: ""
        connection: muxed
        desc: ""
        domain: Aon
        glob_idx: 89
      }
      {
        name: sysrst_ctrl_key2_in
        width: 1
        type: input
        idx: -1
        pads: []
        attr: ""
        connection: muxed
        desc: ""
        domain: Aon
        glob_idx: 90
      }
      {
        name: sysrst_ctrl_pwrb_in
        width: 1
        type: input
        idx: -1
        pads: []
        attr: ""
        connection: muxed
        desc: ""
        domain: Aon
        glob_idx: 91
      }
      {
        name: sysrst_ctrl_lid_open
        width: 1
        type: input
        idx: -1
        pads: []
        attr: ""
        connection: muxed
        desc: ""
        domain: Aon
        glob_idx: 92
      }
      {
        name: usbdev_sense
        width: 1
        type: input
        idx: -1
        pads: []
        attr: ""
        connection: muxed
        desc: ""
        domain: Main
        glob_idx: 93
      }
      {
        name: spi_host0_sck
        width: 1
        type: output
        idx: -1
        pads:
        [
          SPI_HOST_CLK
        ]
        attr: BidirStr
        connection: direct
        desc: ""
        domain: Main
        glob_idx: 14
      }
      {
        name: spi_host0_csb
        width: 3
        type: output
        idx: 0
        pads:
        [
          SPI_HOST_CS_L
        ]
        attr: BidirStr
        connection: direct
        desc: ""
        domain: Main
        glob_idx: 15
      }
      {
        name: uart0_tx
        width: 1
        type: output
        idx: -1
        pads: []
        attr: ""
        connection: muxed
        desc: ""
        domain: Main
        glob_idx: 78
      }
      {
        name: uart1_tx
        width: 1
        type: output
        idx: -1
        pads: []
        attr: ""
        connection: muxed
        desc: ""
        domain: Main
        glob_idx: 79
      }
      {
        name: uart2_tx
        width: 1
        type: output
        idx: -1
        pads: []
        attr: ""
        connection: muxed
        desc: ""
        domain: Main
        glob_idx: 80
      }
      {
        name: uart3_tx
        width: 1
        type: output
        idx: -1
        pads: []
        attr: ""
        connection: muxed
        desc: ""
        domain: Main
        glob_idx: 81
      }
      {
        name: i3c0_ctrl_sda_pu
        width: 1
        type: output
        idx: -1
        pads: []
        attr: ""
        connection: muxed
        desc: ""
        domain: Main
        glob_idx: 82
      }
      {
        name: i3c1_ctrl_sda_pu
        width: 1
        type: output
        idx: -1
        pads: []
        attr: ""
        connection: muxed
        desc: ""
        domain: Main
        glob_idx: 83
      }
      {
        name: spi_host0_csb
        width: 3
        type: output
        idx: 1
        pads: []
        attr: ""
        connection: muxed
        desc: ""
        domain: Main
        glob_idx: 84
      }
      {
        name: spi_host0_csb
        width: 3
        type: output
        idx: 2
        pads: []
        attr: ""
        connection: muxed
        desc: ""
        domain: Main
        glob_idx: 85
      }
      {
        name: spi_host1_sck
        width: 1
        type: output
        idx: -1
        pads: []
        attr: ""
        connection: muxed
        desc: ""
        domain: Main
        glob_idx: 86
      }
      {
        name: spi_host1_csb
        width: 3
        type: output
        idx: 0
        pads: []
        attr: ""
        connection: muxed
        desc: ""
        domain: Main
        glob_idx: 87
      }
      {
        name: spi_host1_csb
        width: 3
        type: output
        idx: 1
        pads: []
        attr: ""
        connection: muxed
        desc: ""
        domain: Main
        glob_idx: 88
      }
      {
        name: spi_host1_csb
        width: 3
        type: output
        idx: 2
        pads: []
        attr: ""
        connection: muxed
        desc: ""
        domain: Main
        glob_idx: 89
      }
      {
        name: sensor_ctrl_ast_debug_out
        width: 9
        type: output
        idx: 0
        pads: []
        attr: ""
        connection: muxed
        desc: ""
        domain: Aon
        glob_idx: 90
      }
      {
        name: sensor_ctrl_ast_debug_out
        width: 9
        type: output
        idx: 1
        pads: []
        attr: ""
        connection: muxed
        desc: ""
        domain: Aon
        glob_idx: 91
      }
      {
        name: sensor_ctrl_ast_debug_out
        width: 9
        type: output
        idx: 2
        pads: []
        attr: ""
        connection: muxed
        desc: ""
        domain: Aon
        glob_idx: 92
      }
      {
        name: sensor_ctrl_ast_debug_out
        width: 9
        type: output
        idx: 3
        pads: []
        attr: ""
        connection: muxed
        desc: ""
        domain: Aon
        glob_idx: 93
      }
      {
        name: sensor_ctrl_ast_debug_out
        width: 9
        type: output
        idx: 4
        pads: []
        attr: ""
        connection: muxed
        desc: ""
        domain: Aon
        glob_idx: 94
      }
      {
        name: sensor_ctrl_ast_debug_out
        width: 9
        type: output
        idx: 5
        pads: []
        attr: ""
        connection: muxed
        desc: ""
        domain: Aon
        glob_idx: 95
      }
      {
        name: sensor_ctrl_ast_debug_out
        width: 9
        type: output
        idx: 6
        pads: []
        attr: ""
        connection: muxed
        desc: ""
        domain: Aon
        glob_idx: 96
      }
      {
        name: sensor_ctrl_ast_debug_out
        width: 9
        type: output
        idx: 7
        pads: []
        attr: ""
        connection: muxed
        desc: ""
        domain: Aon
        glob_idx: 97
      }
      {
        name: sensor_ctrl_ast_debug_out
        width: 9
        type: output
        idx: 8
        pads: []
        attr: ""
        connection: muxed
        desc: ""
        domain: Aon
        glob_idx: 98
      }
      {
        name: sysrst_ctrl_bat_disable
        width: 1
        type: output
        idx: -1
        pads: []
        attr: ""
        connection: muxed
        desc: ""
        domain: Aon
        glob_idx: 99
      }
      {
        name: sysrst_ctrl_key0_out
        width: 1
        type: output
        idx: -1
        pads: []
        attr: ""
        connection: muxed
        desc: ""
        domain: Aon
        glob_idx: 100
      }
      {
        name: sysrst_ctrl_key1_out
        width: 1
        type: output
        idx: -1
        pads: []
        attr: ""
        connection: muxed
        desc: ""
        domain: Aon
        glob_idx: 101
      }
      {
        name: sysrst_ctrl_key2_out
        width: 1
        type: output
        idx: -1
        pads: []
        attr: ""
        connection: muxed
        desc: ""
        domain: Aon
        glob_idx: 102
      }
      {
        name: sysrst_ctrl_pwrb_out
        width: 1
        type: output
        idx: -1
        pads: []
        attr: ""
        connection: muxed
        desc: ""
        domain: Aon
        glob_idx: 103
      }
      {
        name: sysrst_ctrl_z3_wakeup
        width: 1
        type: output
        idx: -1
        pads: []
        attr: ""
        connection: muxed
        desc: ""
        domain: Aon
        glob_idx: 104
      }
    ]
    io_counts:
    {
      dedicated:
      {
        inouts: 12
        inputs: 2
        outputs: 2
        pads: 21
      }
      muxed:
      {
        inouts: 78
        inputs: 16
        outputs: 27
        pads: 47
      }
    }
  }
  targets:
  [
    {
      name: asic
      chiplevel:
      {
        port_overrides:
        {
          rram_macro.rram_test_analog:
          {
            signal: RRAM_ANALOG
          }
          usbdev.usb_rx_d:
          {
            signal: usb_rx_d
          }
          usbdev.usb_rx_enable:
          {
            signal: usb_rx_enable
          }
          usbdev.usb_tx_d:
          {
            unused: true
          }
          usbdev.usb_tx_se0:
          {
            unused: true
          }
          usbdev.usb_tx_use_d_se0:
          {
            unused: true
          }
          pinmux.dft_hold_tap_sel:
          {
            unused: true
          }
          pinmux.usb_dppullup_en:
          {
            signal: usb_dp_pullup_en
          }
          pinmux.usb_dnpullup_en:
          {
            signal: usb_dn_pullup_en
          }
          ast.scan_shift_en:
          {
            unused: true
          }
          ast.scan_reset_n:
          {
            unused: true
          }
        }
      }
      pinout:
      {
        remove_ports: []
        remove_pads: []
        add_pads: []
      }
      pinmux:
      {
        special_signals:
        [
          {
            name: tap0
            pad: IOC8
            desc: TAP strap signal.
            idx: 30
          }
          {
            name: tap1
            pad: IOC5
            desc: TAP strap signal.
            idx: 27
          }
          {
            name: dft0
            pad: IOR5
            desc: DFT strap signal.
            idx: 40
          }
          {
            name: dft1
            pad: IOR7
            desc: DFT strap signal.
            idx: 42
          }
          {
            name: tck
            pad: IOR3
            desc: JTAG tck signal.
            idx: 38
          }
          {
            name: tms
            pad: IOR0
            desc: JTAG tms signal.
            idx: 35
          }
          {
            name: trst_n
            pad: IOR4
            desc: JTAG trst_n signal.
            idx: 39
          }
          {
            name: tdi
            pad: IOR2
            desc: JTAG tdi signal.
            idx: 37
          }
          {
            name: tdo
            pad: IOR1
            desc: JTAG tdo signal.
            idx: 36
          }
        ]
      }
    }
    {
      name: verilator
      chiplevel:
      {
        port_overrides:
        {
          rram_macro.rram_test_analog:
          {
            unused: true
            tie_value: ""
          }
          sensor_ctrl.manual_pad_attr:
          {
            unused: true
          }
          usbdev.usb_rx_d:
          {
            signal: usb_rx_d
          }
          usbdev.usb_rx_enable:
          {
            signal: usb_rx_enable
          }
          usbdev.usb_tx_d:
          {
            signal: usb_tx_d
          }
          usbdev.usb_tx_se0:
          {
            signal: usb_tx_se0
          }
          usbdev.usb_tx_use_d_se0:
          {
            signal: usb_tx_use_d_se0
          }
          pinmux.dft_hold_tap_sel:
          {
            unused: true
          }
          pinmux.usb_dppullup_en:
          {
            signal: usb_dp_pullup_en
          }
          pinmux.usb_dnpullup_en:
          {
            signal: usb_dn_pullup_en
          }
          ast.por_n:
          {
            signal: rst_n
          }
          ast.pora_n:
          {
            signal: rst_n
          }
          ast.scan_shift_en:
          {
            unused: true
          }
          ast.scan_reset_n:
          {
            unused: true
          }
          ast.usb_io_pu_cal:
          {
            unused: true
          }
        }
      }
      pinout:
      {
        remove_ports: []
        remove_pads: []
        add_pads: []
      }
      pinmux:
      {
        special_signals:
        [
          {
            name: tap0
            pad: IOC8
            desc: TAP strap signal.
            idx: 30
          }
          {
            name: tap1
            pad: IOC5
            desc: TAP strap signal.
            idx: 27
          }
          {
            name: dft0
            pad: IOR5
            desc: DFT strap signal.
            idx: 40
          }
          {
            name: dft1
            pad: IOR7
            desc: DFT strap signal.
            idx: 42
          }
          {
            name: tck
            pad: IOR3
            desc: JTAG tck signal.
            idx: 38
          }
          {
            name: tms
            pad: IOR0
            desc: JTAG tms signal.
            idx: 35
          }
          {
            name: trst_n
            pad: IOR4
            desc: JTAG trst_n signal.
            idx: 39
          }
          {
            name: tdi
            pad: IOR2
            desc: JTAG tdi signal.
            idx: 37
          }
          {
            name: tdo
            pad: IOR1
            desc: JTAG tdo signal.
            idx: 36
          }
        ]
      }
    }
    {
      name: cw340
      chiplevel:
      {
        port_overrides:
        {
          pinmux.dft_hold_tap_sel:
          {
            unused: true
          }
          pinmux.usb_dppullup_en:
          {
            signal: usb_dp_pullup_en
          }
          pinmux.usb_dnpullup_en:
          {
            unused: true
          }
          usbdev.usb_tx_d:
          {
            unused: true
          }
          usbdev.usb_tx_se0:
          {
            unused: true
          }
          usbdev.usb_tx_use_d_se0:
          {
            unused: true
          }
          usbdev.usb_rx_d:
          {
            signal: usb_rx_d
          }
          usbdev.usb_rx_enable:
          {
            signal: usb_rx_enable
          }
          sensor_ctrl.manual_pad_attr:
          {
            unused: true
          }
          rram_macro.rram_test_analog:
          {
            unused: true
          }
          ast.por_n:
          {
            signal: rst_n
          }
          ast.pora_n:
          {
            signal: rst_n
          }
          ast.scan_shift_en:
          {
            unused: true
          }
          ast.scan_reset_n:
          {
            unused: true
          }
          ast.usb_io_pu_cal:
          {
            unused: true
          }
        }
      }
      pinout:
      {
        remove_ports: []
        remove_pads:
        [
          PORA_N
          CC1
          CC2
          RRAM_ANALOG
          USB_P
          USB_N
        ]
        add_pads:
        [
          {
            name: IO_CLK
            type: InputStd
            bank: VCC
            connection: manual
            desc: Extra clock input for FPGA target
            port_type: inout
          }
          {
            name: IO_USB_CONNECT
            type: BidirStd
            bank: VCC
            connection: manual
            desc: Manual USB UPHY signal for FPGA target
            port_type: inout
          }
          {
            name: IO_USB_DP_TX
            type: BidirStd
            bank: VCC
            connection: manual
            desc: Manual USB UPHY signal for FPGA target
            port_type: inout
          }
          {
            name: IO_USB_DN_TX
            type: BidirStd
            bank: VCC
            connection: manual
            desc: Manual USB UPHY signal for FPGA target
            port_type: inout
          }
          {
            name: IO_USB_D_RX
            type: BidirStd
            bank: VCC
            connection: manual
            desc: Manual USB UPHY signal for FPGA target
            port_type: inout
          }
          {
            name: IO_USB_DP_RX
            type: BidirStd
            bank: VCC
            connection: manual
            desc: Manual USB UPHY signal for FPGA target
            port_type: inout
          }
          {
            name: IO_USB_DN_RX
            type: BidirStd
            bank: VCC
            connection: manual
            desc: Manual USB UPHY signal for FPGA target
            port_type: inout
          }
          {
            name: IO_USB_OE_N
            type: BidirStd
            bank: VCC
            connection: manual
            desc: Manual USB UPHY signal for FPGA target
            port_type: inout
          }
          {
            name: IO_USB_SPEED
            type: BidirStd
            bank: VCC
            connection: manual
            desc: Manual USB UPHY signal for FPGA target
            port_type: inout
          }
          {
            name: IO_USB_SUSPEND
            type: BidirStd
            bank: VCC
            connection: manual
            desc: Manual USB UPHY signal for FPGA target
            port_type: inout
          }
          {
            name: IO_CLKOUT
            type: BidirStd
            bank: VCC
            connection: manual
            desc: Manual clock output for SCA setup
            port_type: inout
          }
          {
            name: IO_TRIGGER
            type: BidirStd
            bank: VCC
            connection: manual
            desc: Manual trigger output for SCA setup
            port_type: inout
          }
        ]
      }
      pinmux:
      {
        special_signals:
        [
          {
            name: tap0
            pad: IOC8
            desc: TAP strap signal.
            idx: 30
          }
          {
            name: tap1
            pad: IOC5
            desc: TAP strap signal.
            idx: 27
          }
          {
            name: dft0
            pad: IOR5
            desc: DFT strap signal.
            idx: 40
          }
          {
            name: dft1
            pad: IOR7
            desc: DFT strap signal.
            idx: 42
          }
          {
            name: tck
            pad: IOR3
            desc: JTAG tck signal.
            idx: 38
          }
          {
            name: tms
            pad: IOR0
            desc: JTAG tms signal.
            idx: 35
          }
          {
            name: trst_n
            pad: IOR4
            desc: JTAG trst_n signal.
            idx: 39
          }
          {
            name: tdi
            pad: IOR2
            desc: JTAG tdi signal.
            idx: 37
          }
          {
            name: tdo
            pad: IOR1
            desc: JTAG tdo signal.
            idx: 36
          }
        ]
      }
    }
  ]
  incoming_alert: {}
  incoming_interrupt: {}
  exported_clks: {}
  wakeups:
  [
    {
      name: rstdet_wkup_req
      width: "1"
      module: i3c0
    }
    {
      name: rstdet_wkup_req
      width: "1"
      module: i3c1
    }
    {
      name: wkup_req
      width: "1"
      module: sysrst_ctrl
    }
    {
      name: wkup_req
      width: "1"
      module: adc_ctrl
    }
    {
      name: pin_wkup_req
      width: "1"
      module: pinmux
    }
    {
      name: usb_wkup_req
      width: "1"
      module: pinmux
    }
    {
      name: wkup_req
      width: "1"
      module: aon_timer
    }
    {
      name: wkup_req
      width: "1"
      module: sensor_ctrl
    }
  ]
  unmanaged_resets: {}
  exported_rsts: {}
  alert:
  [
    {
      name: uart0_fatal_fault
      width: 1
      type: alert
      async: "1"
      handler: alert_handler
      module_name: uart0
      desc: uart0 fatal_fault alert
      lpg_name: peri_lc_io_div4_Main
      lpg_idx: 0
    }
    {
      name: uart1_fatal_fault
      width: 1
      type: alert
      async: "1"
      handler: alert_handler
      module_name: uart1
      desc: uart1 fatal_fault alert
      lpg_name: peri_lc_io_div4_Main
      lpg_idx: 0
    }
    {
      name: uart2_fatal_fault
      width: 1
      type: alert
      async: "1"
      handler: alert_handler
      module_name: uart2
      desc: uart2 fatal_fault alert
      lpg_name: peri_lc_io_div4_Main
      lpg_idx: 0
    }
    {
      name: uart3_fatal_fault
      width: 1
      type: alert
      async: "1"
      handler: alert_handler
      module_name: uart3
      desc: uart3 fatal_fault alert
      lpg_name: peri_lc_io_div4_Main
      lpg_idx: 0
    }
    {
      name: gpio0_fatal_fault
      width: 1
      type: alert
      async: "1"
      handler: alert_handler
      module_name: gpio0
      desc: gpio0 fatal_fault alert
      lpg_name: peri_lc_io_div4_Main
      lpg_idx: 0
    }
    {
      name: gpio1_fatal_fault
      width: 1
      type: alert
      async: "1"
      handler: alert_handler
      module_name: gpio1
      desc: gpio1 fatal_fault alert
      lpg_name: peri_lc_io_div4_Main
      lpg_idx: 0
    }
    {
      name: spi_device_fatal_fault
      width: 1
      type: alert
      async: "1"
      handler: alert_handler
      module_name: spi_device
      desc: spi_device fatal_fault alert
      lpg_name: peri_spi_device_Main
      lpg_idx: 1
    }
    {
      name: i2c0_fatal_fault
      width: 1
      type: alert
      async: "1"
      handler: alert_handler
      module_name: i2c0
      desc: i2c0 fatal_fault alert
      lpg_name: peri_i2c0_Main
      lpg_idx: 2
    }
    {
      name: i2c1_fatal_fault
      width: 1
      type: alert
      async: "1"
      handler: alert_handler
      module_name: i2c1
      desc: i2c1 fatal_fault alert
      lpg_name: peri_i2c1_Main
      lpg_idx: 3
    }
    {
      name: i2c2_fatal_fault
      width: 1
      type: alert
      async: "1"
      handler: alert_handler
      module_name: i2c2
      desc: i2c2 fatal_fault alert
      lpg_name: peri_i2c2_Main
      lpg_idx: 4
    }
    {
      name: i3c0_fatal_fault
      width: 1
      type: alert
      async: "1"
      handler: alert_handler
      module_name: i3c0
      desc: i3c0 fatal_fault alert
      lpg_name: peri_i3c0_Main
      lpg_idx: 5
    }
    {
      name: i3c1_fatal_fault
      width: 1
      type: alert
      async: "1"
      handler: alert_handler
      module_name: i3c1
      desc: i3c1 fatal_fault alert
      lpg_name: peri_i3c1_Main
      lpg_idx: 7
    }
    {
      name: rv_timer_fatal_fault
      width: 1
      type: alert
      async: "1"
      handler: alert_handler
      module_name: rv_timer
      desc: rv_timer fatal_fault alert
      lpg_name: timers_lc_io_div4_Main
      lpg_idx: 9
    }
    {
      name: otp_ctrl_fatal_macro_error
      width: 1
      type: alert
      async: "1"
      handler: alert_handler
      module_name: otp_ctrl
      desc: otp_ctrl fatal_macro_error alert
      lpg_name: secure_lc_io_div4_Main
      lpg_idx: 10
    }
    {
      name: otp_ctrl_fatal_check_error
      width: 1
      type: alert
      async: "1"
      handler: alert_handler
      module_name: otp_ctrl
      desc: otp_ctrl fatal_check_error alert
      lpg_name: secure_lc_io_div4_Main
      lpg_idx: 10
    }
    {
      name: otp_ctrl_fatal_bus_integ_error
      width: 1
      type: alert
      async: "1"
      handler: alert_handler
      module_name: otp_ctrl
      desc: otp_ctrl fatal_bus_integ_error alert
      lpg_name: secure_lc_io_div4_Main
      lpg_idx: 10
    }
    {
      name: otp_ctrl_fatal_prim_otp_alert
      width: 1
      type: alert
      async: "1"
      handler: alert_handler
      module_name: otp_ctrl
      desc: otp_ctrl fatal_prim_otp_alert alert
      lpg_name: secure_lc_io_div4_Main
      lpg_idx: 10
    }
    {
      name: otp_ctrl_recov_prim_otp_alert
      width: 1
      type: alert
      async: "1"
      handler: alert_handler
      module_name: otp_ctrl
      desc: otp_ctrl recov_prim_otp_alert alert
      lpg_name: secure_lc_io_div4_Main
      lpg_idx: 10
    }
    {
      name: lc_ctrl_fatal_prog_error
      width: 1
      type: alert
      async: "1"
      handler: alert_handler
      module_name: lc_ctrl
      desc: lc_ctrl fatal_prog_error alert
      lpg_name: secure_lc_io_div4_Main
      lpg_idx: 10
    }
    {
      name: lc_ctrl_fatal_state_error
      width: 1
      type: alert
      async: "1"
      handler: alert_handler
      module_name: lc_ctrl
      desc: lc_ctrl fatal_state_error alert
      lpg_name: secure_lc_io_div4_Main
      lpg_idx: 10
    }
    {
      name: lc_ctrl_fatal_bus_integ_error
      width: 1
      type: alert
      async: "1"
      handler: alert_handler
      module_name: lc_ctrl
      desc: lc_ctrl fatal_bus_integ_error alert
      lpg_name: secure_lc_io_div4_Main
      lpg_idx: 10
    }
    {
      name: spi_host0_fatal_fault
      width: 1
      type: alert
      async: "1"
      handler: alert_handler
      module_name: spi_host0
      desc: spi_host0 fatal_fault alert
      lpg_name: peri_spi_host0_Main
      lpg_idx: 11
    }
    {
      name: spi_host1_fatal_fault
      width: 1
      type: alert
      async: "1"
      handler: alert_handler
      module_name: spi_host1
      desc: spi_host1 fatal_fault alert
      lpg_name: spi_host1_spi_host1_Main
      lpg_idx: 12
    }
    {
      name: usbdev_fatal_fault
      width: 1
      type: alert
      async: "1"
      handler: alert_handler
      module_name: usbdev
      desc: usbdev fatal_fault alert
      lpg_name: peri_usb_Main
      lpg_idx: 13
    }
    {
      name: pwrmgr_fatal_fault
      width: 1
      type: alert
      async: "1"
      handler: alert_handler
      module_name: pwrmgr
      desc: pwrmgr fatal_fault alert
      lpg_name: powerup_por_io_div4_Aon
      lpg_idx: 14
    }
    {
      name: rstmgr_fatal_fault
      width: 1
      type: alert
      async: "1"
      handler: alert_handler
      module_name: rstmgr
      desc: rstmgr fatal_fault alert
      lpg_name: powerup_lc_io_div4_Aon
      lpg_idx: 15
    }
    {
      name: rstmgr_fatal_cnsty_fault
      width: 1
      type: alert
      async: "1"
      handler: alert_handler
      module_name: rstmgr
      desc: rstmgr fatal_cnsty_fault alert
      lpg_name: powerup_lc_io_div4_Aon
      lpg_idx: 15
    }
    {
      name: clkmgr_recov_fault
      width: 1
      type: alert
      async: "1"
      handler: alert_handler
      module_name: clkmgr
      desc: clkmgr recov_fault alert
      lpg_name: powerup_lc_io_div4_Aon
      lpg_idx: 15
    }
    {
      name: clkmgr_fatal_fault
      width: 1
      type: alert
      async: "1"
      handler: alert_handler
      module_name: clkmgr
      desc: clkmgr fatal_fault alert
      lpg_name: powerup_lc_io_div4_Aon
      lpg_idx: 15
    }
    {
      name: sysrst_ctrl_fatal_fault
      width: 1
      type: alert
      async: "1"
      handler: alert_handler
      module_name: sysrst_ctrl
      desc: sysrst_ctrl fatal_fault alert
      lpg_name: secure_lc_io_div4_Aon
      lpg_idx: 16
    }
    {
      name: adc_ctrl_fatal_fault
      width: 1
      type: alert
      async: "1"
      handler: alert_handler
      module_name: adc_ctrl
      desc: adc_ctrl fatal_fault alert
      lpg_name: peri_lc_io_div4_Aon
      lpg_idx: 17
    }
    {
      name: pinmux_fatal_fault
      width: 1
      type: alert
      async: "1"
      handler: alert_handler
      module_name: pinmux
      desc: pinmux fatal_fault alert
      lpg_name: powerup_lc_io_div4_Aon
      lpg_idx: 15
    }
    {
      name: aon_timer_fatal_fault
      width: 1
      type: alert
      async: "1"
      handler: alert_handler
      module_name: aon_timer
      desc: aon_timer fatal_fault alert
      lpg_name: timers_lc_io_div4_Aon
      lpg_idx: 18
    }
    {
      name: sensor_ctrl_recov_alert
      width: 1
      type: alert
      async: "1"
      handler: alert_handler
      module_name: sensor_ctrl
      desc: sensor_ctrl recov_alert alert
      lpg_name: secure_lc_io_div4_Aon
      lpg_idx: 16
    }
    {
      name: sensor_ctrl_fatal_alert
      width: 1
      type: alert
      async: "1"
      handler: alert_handler
      module_name: sensor_ctrl
      desc: sensor_ctrl fatal_alert alert
      lpg_name: secure_lc_io_div4_Aon
      lpg_idx: 16
    }
    {
      name: sram_ctrl_ret_fatal_error
      width: 1
      type: alert
      async: "1"
      handler: alert_handler
      module_name: sram_ctrl_ret
      desc: sram_ctrl_ret fatal_error alert
      lpg_name: infra_lc_io_div4_Aon
      lpg_idx: 20
    }
    {
      name: rram_ctrl_recov_err
      width: 1
      type: alert
      async: "1"
      handler: alert_handler
      module_name: rram_ctrl
      desc: rram_ctrl recov_err alert
      lpg_name: infra_lc_Main
      lpg_idx: 21
    }
    {
      name: rram_ctrl_fatal_std_err
      width: 1
      type: alert
      async: "1"
      handler: alert_handler
      module_name: rram_ctrl
      desc: rram_ctrl fatal_std_err alert
      lpg_name: infra_lc_Main
      lpg_idx: 21
    }
    {
      name: rram_ctrl_fatal_err
      width: 1
      type: alert
      async: "1"
      handler: alert_handler
      module_name: rram_ctrl
      desc: rram_ctrl fatal_err alert
      lpg_name: infra_lc_Main
      lpg_idx: 21
    }
    {
      name: rram_ctrl_fatal_macro_err
      width: 1
      type: alert
      async: "1"
      handler: alert_handler
      module_name: rram_ctrl
      desc: rram_ctrl fatal_macro_err alert
      lpg_name: infra_lc_Main
      lpg_idx: 21
    }
    {
      name: rram_ctrl_recov_macro_err
      width: 1
      type: alert
      async: "1"
      handler: alert_handler
      module_name: rram_ctrl
      desc: rram_ctrl recov_macro_err alert
      lpg_name: infra_lc_Main
      lpg_idx: 21
    }
    {
      name: rv_dm_fatal_fault
      width: 1
      type: alert
      async: "1"
      handler: alert_handler
      module_name: rv_dm
      desc: rv_dm fatal_fault alert
      lpg_name: infra_sys_Main
      lpg_idx: 22
    }
    {
      name: rv_plic_fatal_fault
      width: 1
      type: alert
      async: "1"
      handler: alert_handler
      module_name: rv_plic
      desc: rv_plic fatal_fault alert
      lpg_name: secure_lc_Main
      lpg_idx: 23
    }
    {
      name: aes_recov_ctrl_update_err
      width: 1
      type: alert
      async: "1"
      handler: alert_handler
      module_name: aes
      desc: aes recov_ctrl_update_err alert
      lpg_name: aes_trans_lc_Main
      lpg_idx: 24
    }
    {
      name: aes_fatal_fault
      width: 1
      type: alert
      async: "1"
      handler: alert_handler
      module_name: aes
      desc: aes fatal_fault alert
      lpg_name: aes_trans_lc_Main
      lpg_idx: 24
    }
    {
      name: hmac_fatal_fault
      width: 1
      type: alert
      async: "1"
      handler: alert_handler
      module_name: hmac
      desc: hmac fatal_fault alert
      lpg_name: hmac_trans_lc_Main
      lpg_idx: 25
    }
    {
      name: kmac_recov_operation_err
      width: 1
      type: alert
      async: "1"
      handler: alert_handler
      module_name: kmac
      desc: kmac recov_operation_err alert
      lpg_name: kmac_trans_lc_Main
      lpg_idx: 26
    }
    {
      name: kmac_fatal_fault_err
      width: 1
      type: alert
      async: "1"
      handler: alert_handler
      module_name: kmac
      desc: kmac fatal_fault_err alert
      lpg_name: kmac_trans_lc_Main
      lpg_idx: 26
    }
    {
      name: otbn_fatal
      width: 1
      type: alert
      async: "1"
      handler: alert_handler
      module_name: otbn
      desc: otbn fatal alert
      lpg_name: otbn_trans_lc_Main
      lpg_idx: 27
    }
    {
      name: otbn_recov
      width: 1
      type: alert
      async: "1"
      handler: alert_handler
      module_name: otbn
      desc: otbn recov alert
      lpg_name: otbn_trans_lc_Main
      lpg_idx: 27
    }
    {
      name: keymgr_dpe_recov_operation_err
      width: 1
      type: alert
      async: "1"
      handler: alert_handler
      module_name: keymgr_dpe
      desc: keymgr_dpe recov_operation_err alert
      lpg_name: secure_lc_Main
      lpg_idx: 23
    }
    {
      name: keymgr_dpe_fatal_fault_err
      width: 1
      type: alert
      async: "1"
      handler: alert_handler
      module_name: keymgr_dpe
      desc: keymgr_dpe fatal_fault_err alert
      lpg_name: secure_lc_Main
      lpg_idx: 23
    }
    {
      name: csrng_recov_alert
      width: 1
      type: alert
      async: "1"
      handler: alert_handler
      module_name: csrng
      desc: csrng recov_alert alert
      lpg_name: secure_lc_Main
      lpg_idx: 23
    }
    {
      name: csrng_fatal_alert
      width: 1
      type: alert
      async: "1"
      handler: alert_handler
      module_name: csrng
      desc: csrng fatal_alert alert
      lpg_name: secure_lc_Main
      lpg_idx: 23
    }
    {
      name: entropy_src_recov_alert
      width: 1
      type: alert
      async: "1"
      handler: alert_handler
      module_name: entropy_src
      desc: entropy_src recov_alert alert
      lpg_name: secure_lc_Main
      lpg_idx: 23
    }
    {
      name: entropy_src_fatal_alert
      width: 1
      type: alert
      async: "1"
      handler: alert_handler
      module_name: entropy_src
      desc: entropy_src fatal_alert alert
      lpg_name: secure_lc_Main
      lpg_idx: 23
    }
    {
      name: edn0_recov_alert
      width: 1
      type: alert
      async: "1"
      handler: alert_handler
      module_name: edn0
      desc: edn0 recov_alert alert
      lpg_name: secure_lc_Main
      lpg_idx: 23
    }
    {
      name: edn0_fatal_alert
      width: 1
      type: alert
      async: "1"
      handler: alert_handler
      module_name: edn0
      desc: edn0 fatal_alert alert
      lpg_name: secure_lc_Main
      lpg_idx: 23
    }
    {
      name: edn1_recov_alert
      width: 1
      type: alert
      async: "1"
      handler: alert_handler
      module_name: edn1
      desc: edn1 recov_alert alert
      lpg_name: secure_lc_Main
      lpg_idx: 23
    }
    {
      name: edn1_fatal_alert
      width: 1
      type: alert
      async: "1"
      handler: alert_handler
      module_name: edn1
      desc: edn1 fatal_alert alert
      lpg_name: secure_lc_Main
      lpg_idx: 23
    }
    {
      name: sram_ctrl_main_fatal_error
      width: 1
      type: alert
      async: "1"
      handler: alert_handler
      module_name: sram_ctrl_main
      desc: sram_ctrl_main fatal_error alert
      lpg_name: infra_lc_Main
      lpg_idx: 21
    }
    {
      name: sram_ctrl_sec_fatal_error
      width: 1
      type: alert
      async: "1"
      handler: alert_handler
      module_name: sram_ctrl_sec
      desc: sram_ctrl_sec fatal_error alert
      lpg_name: infra_lc_Main
      lpg_idx: 21
    }
    {
      name: rom_ctrl_fatal
      width: 1
      type: alert
      async: "1"
      handler: alert_handler
      module_name: rom_ctrl
      desc: rom_ctrl fatal alert
      lpg_name: infra_lc_Main
      lpg_idx: 21
    }
    {
      name: rv_core_ibex_fatal_sw_err
      width: 1
      type: alert
      async: "1"
      handler: alert_handler
      module_name: rv_core_ibex
      desc: rv_core_ibex fatal_sw_err alert
      lpg_name: infra_lc_Main
      lpg_idx: 21
    }
    {
      name: rv_core_ibex_recov_sw_err
      width: 1
      type: alert
      async: "1"
      handler: alert_handler
      module_name: rv_core_ibex
      desc: rv_core_ibex recov_sw_err alert
      lpg_name: infra_lc_Main
      lpg_idx: 21
    }
    {
      name: rv_core_ibex_fatal_hw_err
      width: 1
      type: alert
      async: "1"
      handler: alert_handler
      module_name: rv_core_ibex
      desc: rv_core_ibex fatal_hw_err alert
      lpg_name: infra_lc_Main
      lpg_idx: 21
    }
    {
      name: rv_core_ibex_recov_hw_err
      width: 1
      type: alert
      async: "1"
      handler: alert_handler
      module_name: rv_core_ibex
      desc: rv_core_ibex recov_hw_err alert
      lpg_name: infra_lc_Main
      lpg_idx: 21
    }
    {
      name: cheriot_mem_sys_fatal_fault
      width: 1
      type: alert
      async: "1"
      handler: alert_handler
      module_name: cheriot_mem_sys
      desc: cheriot_mem_sys fatal_fault alert
      lpg_name: infra_lc_Main
      lpg_idx: 21
    }
    {
      name: sram_ctrl_meta_fatal_error
      width: 1
      type: alert
      async: "1"
      handler: alert_handler
      module_name: sram_ctrl_meta
      desc: sram_ctrl_meta fatal_error alert
      lpg_name: infra_lc_Main
      lpg_idx: 21
    }
  ]
  outgoing_alert: {}
  interrupt:
  [
    {
      name: uart0_tx_watermark
      width: 1
      type: interrupt
      module_name: uart0
      desc: uart0 tx_watermark interrupt
      intr_type: IntrType.Status
      default_val: true
      incoming: false
      domain: Main
      plic: rv_plic
      outgoing: false
    }
    {
      name: uart0_rx_watermark
      width: 1
      type: interrupt
      module_name: uart0
      desc: uart0 rx_watermark interrupt
      intr_type: IntrType.Status
      default_val: false
      incoming: false
      domain: Main
      plic: rv_plic
      outgoing: false
    }
    {
      name: uart0_tx_done
      width: 1
      type: interrupt
      module_name: uart0
      desc: uart0 tx_done interrupt
      intr_type: IntrType.Event
      default_val: false
      incoming: false
      domain: Main
      plic: rv_plic
      outgoing: false
    }
    {
      name: uart0_rx_overflow
      width: 1
      type: interrupt
      module_name: uart0
      desc: uart0 rx_overflow interrupt
      intr_type: IntrType.Event
      default_val: false
      incoming: false
      domain: Main
      plic: rv_plic
      outgoing: false
    }
    {
      name: uart0_rx_frame_err
      width: 1
      type: interrupt
      module_name: uart0
      desc: uart0 rx_frame_err interrupt
      intr_type: IntrType.Event
      default_val: false
      incoming: false
      domain: Main
      plic: rv_plic
      outgoing: false
    }
    {
      name: uart0_rx_break_err
      width: 1
      type: interrupt
      module_name: uart0
      desc: uart0 rx_break_err interrupt
      intr_type: IntrType.Event
      default_val: false
      incoming: false
      domain: Main
      plic: rv_plic
      outgoing: false
    }
    {
      name: uart0_rx_timeout
      width: 1
      type: interrupt
      module_name: uart0
      desc: uart0 rx_timeout interrupt
      intr_type: IntrType.Event
      default_val: false
      incoming: false
      domain: Main
      plic: rv_plic
      outgoing: false
    }
    {
      name: uart0_rx_parity_err
      width: 1
      type: interrupt
      module_name: uart0
      desc: uart0 rx_parity_err interrupt
      intr_type: IntrType.Event
      default_val: false
      incoming: false
      domain: Main
      plic: rv_plic
      outgoing: false
    }
    {
      name: uart0_tx_empty
      width: 1
      type: interrupt
      module_name: uart0
      desc: uart0 tx_empty interrupt
      intr_type: IntrType.Status
      default_val: true
      incoming: false
      domain: Main
      plic: rv_plic
      outgoing: false
    }
    {
      name: uart1_tx_watermark
      width: 1
      type: interrupt
      module_name: uart1
      desc: uart1 tx_watermark interrupt
      intr_type: IntrType.Status
      default_val: true
      incoming: false
      domain: Main
      plic: rv_plic
      outgoing: false
    }
    {
      name: uart1_rx_watermark
      width: 1
      type: interrupt
      module_name: uart1
      desc: uart1 rx_watermark interrupt
      intr_type: IntrType.Status
      default_val: false
      incoming: false
      domain: Main
      plic: rv_plic
      outgoing: false
    }
    {
      name: uart1_tx_done
      width: 1
      type: interrupt
      module_name: uart1
      desc: uart1 tx_done interrupt
      intr_type: IntrType.Event
      default_val: false
      incoming: false
      domain: Main
      plic: rv_plic
      outgoing: false
    }
    {
      name: uart1_rx_overflow
      width: 1
      type: interrupt
      module_name: uart1
      desc: uart1 rx_overflow interrupt
      intr_type: IntrType.Event
      default_val: false
      incoming: false
      domain: Main
      plic: rv_plic
      outgoing: false
    }
    {
      name: uart1_rx_frame_err
      width: 1
      type: interrupt
      module_name: uart1
      desc: uart1 rx_frame_err interrupt
      intr_type: IntrType.Event
      default_val: false
      incoming: false
      domain: Main
      plic: rv_plic
      outgoing: false
    }
    {
      name: uart1_rx_break_err
      width: 1
      type: interrupt
      module_name: uart1
      desc: uart1 rx_break_err interrupt
      intr_type: IntrType.Event
      default_val: false
      incoming: false
      domain: Main
      plic: rv_plic
      outgoing: false
    }
    {
      name: uart1_rx_timeout
      width: 1
      type: interrupt
      module_name: uart1
      desc: uart1 rx_timeout interrupt
      intr_type: IntrType.Event
      default_val: false
      incoming: false
      domain: Main
      plic: rv_plic
      outgoing: false
    }
    {
      name: uart1_rx_parity_err
      width: 1
      type: interrupt
      module_name: uart1
      desc: uart1 rx_parity_err interrupt
      intr_type: IntrType.Event
      default_val: false
      incoming: false
      domain: Main
      plic: rv_plic
      outgoing: false
    }
    {
      name: uart1_tx_empty
      width: 1
      type: interrupt
      module_name: uart1
      desc: uart1 tx_empty interrupt
      intr_type: IntrType.Status
      default_val: true
      incoming: false
      domain: Main
      plic: rv_plic
      outgoing: false
    }
    {
      name: uart2_tx_watermark
      width: 1
      type: interrupt
      module_name: uart2
      desc: uart2 tx_watermark interrupt
      intr_type: IntrType.Status
      default_val: true
      incoming: false
      domain: Main
      plic: rv_plic
      outgoing: false
    }
    {
      name: uart2_rx_watermark
      width: 1
      type: interrupt
      module_name: uart2
      desc: uart2 rx_watermark interrupt
      intr_type: IntrType.Status
      default_val: false
      incoming: false
      domain: Main
      plic: rv_plic
      outgoing: false
    }
    {
      name: uart2_tx_done
      width: 1
      type: interrupt
      module_name: uart2
      desc: uart2 tx_done interrupt
      intr_type: IntrType.Event
      default_val: false
      incoming: false
      domain: Main
      plic: rv_plic
      outgoing: false
    }
    {
      name: uart2_rx_overflow
      width: 1
      type: interrupt
      module_name: uart2
      desc: uart2 rx_overflow interrupt
      intr_type: IntrType.Event
      default_val: false
      incoming: false
      domain: Main
      plic: rv_plic
      outgoing: false
    }
    {
      name: uart2_rx_frame_err
      width: 1
      type: interrupt
      module_name: uart2
      desc: uart2 rx_frame_err interrupt
      intr_type: IntrType.Event
      default_val: false
      incoming: false
      domain: Main
      plic: rv_plic
      outgoing: false
    }
    {
      name: uart2_rx_break_err
      width: 1
      type: interrupt
      module_name: uart2
      desc: uart2 rx_break_err interrupt
      intr_type: IntrType.Event
      default_val: false
      incoming: false
      domain: Main
      plic: rv_plic
      outgoing: false
    }
    {
      name: uart2_rx_timeout
      width: 1
      type: interrupt
      module_name: uart2
      desc: uart2 rx_timeout interrupt
      intr_type: IntrType.Event
      default_val: false
      incoming: false
      domain: Main
      plic: rv_plic
      outgoing: false
    }
    {
      name: uart2_rx_parity_err
      width: 1
      type: interrupt
      module_name: uart2
      desc: uart2 rx_parity_err interrupt
      intr_type: IntrType.Event
      default_val: false
      incoming: false
      domain: Main
      plic: rv_plic
      outgoing: false
    }
    {
      name: uart2_tx_empty
      width: 1
      type: interrupt
      module_name: uart2
      desc: uart2 tx_empty interrupt
      intr_type: IntrType.Status
      default_val: true
      incoming: false
      domain: Main
      plic: rv_plic
      outgoing: false
    }
    {
      name: uart3_tx_watermark
      width: 1
      type: interrupt
      module_name: uart3
      desc: uart3 tx_watermark interrupt
      intr_type: IntrType.Status
      default_val: true
      incoming: false
      domain: Main
      plic: rv_plic
      outgoing: false
    }
    {
      name: uart3_rx_watermark
      width: 1
      type: interrupt
      module_name: uart3
      desc: uart3 rx_watermark interrupt
      intr_type: IntrType.Status
      default_val: false
      incoming: false
      domain: Main
      plic: rv_plic
      outgoing: false
    }
    {
      name: uart3_tx_done
      width: 1
      type: interrupt
      module_name: uart3
      desc: uart3 tx_done interrupt
      intr_type: IntrType.Event
      default_val: false
      incoming: false
      domain: Main
      plic: rv_plic
      outgoing: false
    }
    {
      name: uart3_rx_overflow
      width: 1
      type: interrupt
      module_name: uart3
      desc: uart3 rx_overflow interrupt
      intr_type: IntrType.Event
      default_val: false
      incoming: false
      domain: Main
      plic: rv_plic
      outgoing: false
    }
    {
      name: uart3_rx_frame_err
      width: 1
      type: interrupt
      module_name: uart3
      desc: uart3 rx_frame_err interrupt
      intr_type: IntrType.Event
      default_val: false
      incoming: false
      domain: Main
      plic: rv_plic
      outgoing: false
    }
    {
      name: uart3_rx_break_err
      width: 1
      type: interrupt
      module_name: uart3
      desc: uart3 rx_break_err interrupt
      intr_type: IntrType.Event
      default_val: false
      incoming: false
      domain: Main
      plic: rv_plic
      outgoing: false
    }
    {
      name: uart3_rx_timeout
      width: 1
      type: interrupt
      module_name: uart3
      desc: uart3 rx_timeout interrupt
      intr_type: IntrType.Event
      default_val: false
      incoming: false
      domain: Main
      plic: rv_plic
      outgoing: false
    }
    {
      name: uart3_rx_parity_err
      width: 1
      type: interrupt
      module_name: uart3
      desc: uart3 rx_parity_err interrupt
      intr_type: IntrType.Event
      default_val: false
      incoming: false
      domain: Main
      plic: rv_plic
      outgoing: false
    }
    {
      name: uart3_tx_empty
      width: 1
      type: interrupt
      module_name: uart3
      desc: uart3 tx_empty interrupt
      intr_type: IntrType.Status
      default_val: true
      incoming: false
      domain: Main
      plic: rv_plic
      outgoing: false
    }
    {
      name: gpio0_gpio
      width: 32
      type: interrupt
      module_name: gpio0
      desc: gpio0 gpio interrupt
      intr_type: IntrType.Event
      default_val: false
      incoming: false
      domain: Main
      plic: rv_plic
      outgoing: false
    }
    {
      name: gpio1_gpio
      width: 32
      type: interrupt
      module_name: gpio1
      desc: gpio1 gpio interrupt
      intr_type: IntrType.Event
      default_val: false
      incoming: false
      domain: Main
      plic: rv_plic
      outgoing: false
    }
    {
      name: spi_device_upload_cmdfifo_not_empty
      width: 1
      type: interrupt
      module_name: spi_device
      desc: spi_device upload_cmdfifo_not_empty interrupt
      intr_type: IntrType.Event
      default_val: false
      incoming: false
      domain: Main
      plic: rv_plic
      outgoing: false
    }
    {
      name: spi_device_upload_payload_not_empty
      width: 1
      type: interrupt
      module_name: spi_device
      desc: spi_device upload_payload_not_empty interrupt
      intr_type: IntrType.Event
      default_val: false
      incoming: false
      domain: Main
      plic: rv_plic
      outgoing: false
    }
    {
      name: spi_device_upload_payload_overflow
      width: 1
      type: interrupt
      module_name: spi_device
      desc: spi_device upload_payload_overflow interrupt
      intr_type: IntrType.Event
      default_val: false
      incoming: false
      domain: Main
      plic: rv_plic
      outgoing: false
    }
    {
      name: spi_device_readbuf_watermark
      width: 1
      type: interrupt
      module_name: spi_device
      desc: spi_device readbuf_watermark interrupt
      intr_type: IntrType.Event
      default_val: false
      incoming: false
      domain: Main
      plic: rv_plic
      outgoing: false
    }
    {
      name: spi_device_readbuf_flip
      width: 1
      type: interrupt
      module_name: spi_device
      desc: spi_device readbuf_flip interrupt
      intr_type: IntrType.Event
      default_val: false
      incoming: false
      domain: Main
      plic: rv_plic
      outgoing: false
    }
    {
      name: spi_device_tpm_header_not_empty
      width: 1
      type: interrupt
      module_name: spi_device
      desc: spi_device tpm_header_not_empty interrupt
      intr_type: IntrType.Status
      default_val: false
      incoming: false
      domain: Main
      plic: rv_plic
      outgoing: false
    }
    {
      name: spi_device_tpm_rdfifo_cmd_end
      width: 1
      type: interrupt
      module_name: spi_device
      desc: spi_device tpm_rdfifo_cmd_end interrupt
      intr_type: IntrType.Event
      default_val: false
      incoming: false
      domain: Main
      plic: rv_plic
      outgoing: false
    }
    {
      name: spi_device_tpm_rdfifo_drop
      width: 1
      type: interrupt
      module_name: spi_device
      desc: spi_device tpm_rdfifo_drop interrupt
      intr_type: IntrType.Event
      default_val: false
      incoming: false
      domain: Main
      plic: rv_plic
      outgoing: false
    }
    {
      name: i2c0_fmt_threshold
      width: 1
      type: interrupt
      module_name: i2c0
      desc: i2c0 fmt_threshold interrupt
      intr_type: IntrType.Status
      default_val: false
      incoming: false
      domain: Main
      plic: rv_plic
      outgoing: false
    }
    {
      name: i2c0_rx_threshold
      width: 1
      type: interrupt
      module_name: i2c0
      desc: i2c0 rx_threshold interrupt
      intr_type: IntrType.Status
      default_val: false
      incoming: false
      domain: Main
      plic: rv_plic
      outgoing: false
    }
    {
      name: i2c0_acq_threshold
      width: 1
      type: interrupt
      module_name: i2c0
      desc: i2c0 acq_threshold interrupt
      intr_type: IntrType.Status
      default_val: false
      incoming: false
      domain: Main
      plic: rv_plic
      outgoing: false
    }
    {
      name: i2c0_rx_overflow
      width: 1
      type: interrupt
      module_name: i2c0
      desc: i2c0 rx_overflow interrupt
      intr_type: IntrType.Event
      default_val: false
      incoming: false
      domain: Main
      plic: rv_plic
      outgoing: false
    }
    {
      name: i2c0_controller_halt
      width: 1
      type: interrupt
      module_name: i2c0
      desc: i2c0 controller_halt interrupt
      intr_type: IntrType.Status
      default_val: false
      incoming: false
      domain: Main
      plic: rv_plic
      outgoing: false
    }
    {
      name: i2c0_scl_interference
      width: 1
      type: interrupt
      module_name: i2c0
      desc: i2c0 scl_interference interrupt
      intr_type: IntrType.Event
      default_val: false
      incoming: false
      domain: Main
      plic: rv_plic
      outgoing: false
    }
    {
      name: i2c0_sda_interference
      width: 1
      type: interrupt
      module_name: i2c0
      desc: i2c0 sda_interference interrupt
      intr_type: IntrType.Event
      default_val: false
      incoming: false
      domain: Main
      plic: rv_plic
      outgoing: false
    }
    {
      name: i2c0_stretch_timeout
      width: 1
      type: interrupt
      module_name: i2c0
      desc: i2c0 stretch_timeout interrupt
      intr_type: IntrType.Event
      default_val: false
      incoming: false
      domain: Main
      plic: rv_plic
      outgoing: false
    }
    {
      name: i2c0_sda_unstable
      width: 1
      type: interrupt
      module_name: i2c0
      desc: i2c0 sda_unstable interrupt
      intr_type: IntrType.Event
      default_val: false
      incoming: false
      domain: Main
      plic: rv_plic
      outgoing: false
    }
    {
      name: i2c0_cmd_complete
      width: 1
      type: interrupt
      module_name: i2c0
      desc: i2c0 cmd_complete interrupt
      intr_type: IntrType.Event
      default_val: false
      incoming: false
      domain: Main
      plic: rv_plic
      outgoing: false
    }
    {
      name: i2c0_tx_stretch
      width: 1
      type: interrupt
      module_name: i2c0
      desc: i2c0 tx_stretch interrupt
      intr_type: IntrType.Status
      default_val: false
      incoming: false
      domain: Main
      plic: rv_plic
      outgoing: false
    }
    {
      name: i2c0_tx_threshold
      width: 1
      type: interrupt
      module_name: i2c0
      desc: i2c0 tx_threshold interrupt
      intr_type: IntrType.Status
      default_val: false
      incoming: false
      domain: Main
      plic: rv_plic
      outgoing: false
    }
    {
      name: i2c0_acq_stretch
      width: 1
      type: interrupt
      module_name: i2c0
      desc: i2c0 acq_stretch interrupt
      intr_type: IntrType.Status
      default_val: false
      incoming: false
      domain: Main
      plic: rv_plic
      outgoing: false
    }
    {
      name: i2c0_unexp_stop
      width: 1
      type: interrupt
      module_name: i2c0
      desc: i2c0 unexp_stop interrupt
      intr_type: IntrType.Event
      default_val: false
      incoming: false
      domain: Main
      plic: rv_plic
      outgoing: false
    }
    {
      name: i2c0_host_timeout
      width: 1
      type: interrupt
      module_name: i2c0
      desc: i2c0 host_timeout interrupt
      intr_type: IntrType.Event
      default_val: false
      incoming: false
      domain: Main
      plic: rv_plic
      outgoing: false
    }
    {
      name: i2c1_fmt_threshold
      width: 1
      type: interrupt
      module_name: i2c1
      desc: i2c1 fmt_threshold interrupt
      intr_type: IntrType.Status
      default_val: false
      incoming: false
      domain: Main
      plic: rv_plic
      outgoing: false
    }
    {
      name: i2c1_rx_threshold
      width: 1
      type: interrupt
      module_name: i2c1
      desc: i2c1 rx_threshold interrupt
      intr_type: IntrType.Status
      default_val: false
      incoming: false
      domain: Main
      plic: rv_plic
      outgoing: false
    }
    {
      name: i2c1_acq_threshold
      width: 1
      type: interrupt
      module_name: i2c1
      desc: i2c1 acq_threshold interrupt
      intr_type: IntrType.Status
      default_val: false
      incoming: false
      domain: Main
      plic: rv_plic
      outgoing: false
    }
    {
      name: i2c1_rx_overflow
      width: 1
      type: interrupt
      module_name: i2c1
      desc: i2c1 rx_overflow interrupt
      intr_type: IntrType.Event
      default_val: false
      incoming: false
      domain: Main
      plic: rv_plic
      outgoing: false
    }
    {
      name: i2c1_controller_halt
      width: 1
      type: interrupt
      module_name: i2c1
      desc: i2c1 controller_halt interrupt
      intr_type: IntrType.Status
      default_val: false
      incoming: false
      domain: Main
      plic: rv_plic
      outgoing: false
    }
    {
      name: i2c1_scl_interference
      width: 1
      type: interrupt
      module_name: i2c1
      desc: i2c1 scl_interference interrupt
      intr_type: IntrType.Event
      default_val: false
      incoming: false
      domain: Main
      plic: rv_plic
      outgoing: false
    }
    {
      name: i2c1_sda_interference
      width: 1
      type: interrupt
      module_name: i2c1
      desc: i2c1 sda_interference interrupt
      intr_type: IntrType.Event
      default_val: false
      incoming: false
      domain: Main
      plic: rv_plic
      outgoing: false
    }
    {
      name: i2c1_stretch_timeout
      width: 1
      type: interrupt
      module_name: i2c1
      desc: i2c1 stretch_timeout interrupt
      intr_type: IntrType.Event
      default_val: false
      incoming: false
      domain: Main
      plic: rv_plic
      outgoing: false
    }
    {
      name: i2c1_sda_unstable
      width: 1
      type: interrupt
      module_name: i2c1
      desc: i2c1 sda_unstable interrupt
      intr_type: IntrType.Event
      default_val: false
      incoming: false
      domain: Main
      plic: rv_plic
      outgoing: false
    }
    {
      name: i2c1_cmd_complete
      width: 1
      type: interrupt
      module_name: i2c1
      desc: i2c1 cmd_complete interrupt
      intr_type: IntrType.Event
      default_val: false
      incoming: false
      domain: Main
      plic: rv_plic
      outgoing: false
    }
    {
      name: i2c1_tx_stretch
      width: 1
      type: interrupt
      module_name: i2c1
      desc: i2c1 tx_stretch interrupt
      intr_type: IntrType.Status
      default_val: false
      incoming: false
      domain: Main
      plic: rv_plic
      outgoing: false
    }
    {
      name: i2c1_tx_threshold
      width: 1
      type: interrupt
      module_name: i2c1
      desc: i2c1 tx_threshold interrupt
      intr_type: IntrType.Status
      default_val: false
      incoming: false
      domain: Main
      plic: rv_plic
      outgoing: false
    }
    {
      name: i2c1_acq_stretch
      width: 1
      type: interrupt
      module_name: i2c1
      desc: i2c1 acq_stretch interrupt
      intr_type: IntrType.Status
      default_val: false
      incoming: false
      domain: Main
      plic: rv_plic
      outgoing: false
    }
    {
      name: i2c1_unexp_stop
      width: 1
      type: interrupt
      module_name: i2c1
      desc: i2c1 unexp_stop interrupt
      intr_type: IntrType.Event
      default_val: false
      incoming: false
      domain: Main
      plic: rv_plic
      outgoing: false
    }
    {
      name: i2c1_host_timeout
      width: 1
      type: interrupt
      module_name: i2c1
      desc: i2c1 host_timeout interrupt
      intr_type: IntrType.Event
      default_val: false
      incoming: false
      domain: Main
      plic: rv_plic
      outgoing: false
    }
    {
      name: i2c2_fmt_threshold
      width: 1
      type: interrupt
      module_name: i2c2
      desc: i2c2 fmt_threshold interrupt
      intr_type: IntrType.Status
      default_val: false
      incoming: false
      domain: Main
      plic: rv_plic
      outgoing: false
    }
    {
      name: i2c2_rx_threshold
      width: 1
      type: interrupt
      module_name: i2c2
      desc: i2c2 rx_threshold interrupt
      intr_type: IntrType.Status
      default_val: false
      incoming: false
      domain: Main
      plic: rv_plic
      outgoing: false
    }
    {
      name: i2c2_acq_threshold
      width: 1
      type: interrupt
      module_name: i2c2
      desc: i2c2 acq_threshold interrupt
      intr_type: IntrType.Status
      default_val: false
      incoming: false
      domain: Main
      plic: rv_plic
      outgoing: false
    }
    {
      name: i2c2_rx_overflow
      width: 1
      type: interrupt
      module_name: i2c2
      desc: i2c2 rx_overflow interrupt
      intr_type: IntrType.Event
      default_val: false
      incoming: false
      domain: Main
      plic: rv_plic
      outgoing: false
    }
    {
      name: i2c2_controller_halt
      width: 1
      type: interrupt
      module_name: i2c2
      desc: i2c2 controller_halt interrupt
      intr_type: IntrType.Status
      default_val: false
      incoming: false
      domain: Main
      plic: rv_plic
      outgoing: false
    }
    {
      name: i2c2_scl_interference
      width: 1
      type: interrupt
      module_name: i2c2
      desc: i2c2 scl_interference interrupt
      intr_type: IntrType.Event
      default_val: false
      incoming: false
      domain: Main
      plic: rv_plic
      outgoing: false
    }
    {
      name: i2c2_sda_interference
      width: 1
      type: interrupt
      module_name: i2c2
      desc: i2c2 sda_interference interrupt
      intr_type: IntrType.Event
      default_val: false
      incoming: false
      domain: Main
      plic: rv_plic
      outgoing: false
    }
    {
      name: i2c2_stretch_timeout
      width: 1
      type: interrupt
      module_name: i2c2
      desc: i2c2 stretch_timeout interrupt
      intr_type: IntrType.Event
      default_val: false
      incoming: false
      domain: Main
      plic: rv_plic
      outgoing: false
    }
    {
      name: i2c2_sda_unstable
      width: 1
      type: interrupt
      module_name: i2c2
      desc: i2c2 sda_unstable interrupt
      intr_type: IntrType.Event
      default_val: false
      incoming: false
      domain: Main
      plic: rv_plic
      outgoing: false
    }
    {
      name: i2c2_cmd_complete
      width: 1
      type: interrupt
      module_name: i2c2
      desc: i2c2 cmd_complete interrupt
      intr_type: IntrType.Event
      default_val: false
      incoming: false
      domain: Main
      plic: rv_plic
      outgoing: false
    }
    {
      name: i2c2_tx_stretch
      width: 1
      type: interrupt
      module_name: i2c2
      desc: i2c2 tx_stretch interrupt
      intr_type: IntrType.Status
      default_val: false
      incoming: false
      domain: Main
      plic: rv_plic
      outgoing: false
    }
    {
      name: i2c2_tx_threshold
      width: 1
      type: interrupt
      module_name: i2c2
      desc: i2c2 tx_threshold interrupt
      intr_type: IntrType.Status
      default_val: false
      incoming: false
      domain: Main
      plic: rv_plic
      outgoing: false
    }
    {
      name: i2c2_acq_stretch
      width: 1
      type: interrupt
      module_name: i2c2
      desc: i2c2 acq_stretch interrupt
      intr_type: IntrType.Status
      default_val: false
      incoming: false
      domain: Main
      plic: rv_plic
      outgoing: false
    }
    {
      name: i2c2_unexp_stop
      width: 1
      type: interrupt
      module_name: i2c2
      desc: i2c2 unexp_stop interrupt
      intr_type: IntrType.Event
      default_val: false
      incoming: false
      domain: Main
      plic: rv_plic
      outgoing: false
    }
    {
      name: i2c2_host_timeout
      width: 1
      type: interrupt
      module_name: i2c2
      desc: i2c2 host_timeout interrupt
      intr_type: IntrType.Event
      default_val: false
      incoming: false
      domain: Main
      plic: rv_plic
      outgoing: false
    }
    {
      name: i3c0_hci
      width: 1
      type: interrupt
      module_name: i3c0
      desc: i3c0 hci interrupt
      intr_type: IntrType.Status
      default_val: false
      incoming: false
      domain: Main
      plic: rv_plic
      outgoing: false
    }
    {
      name: i3c0_targ
      width: 1
      type: interrupt
      module_name: i3c0
      desc: i3c0 targ interrupt
      intr_type: IntrType.Status
      default_val: false
      incoming: false
      domain: Main
      plic: rv_plic
      outgoing: false
    }
    {
      name: i3c1_hci
      width: 1
      type: interrupt
      module_name: i3c1
      desc: i3c1 hci interrupt
      intr_type: IntrType.Status
      default_val: false
      incoming: false
      domain: Main
      plic: rv_plic
      outgoing: false
    }
    {
      name: i3c1_targ
      width: 1
      type: interrupt
      module_name: i3c1
      desc: i3c1 targ interrupt
      intr_type: IntrType.Status
      default_val: false
      incoming: false
      domain: Main
      plic: rv_plic
      outgoing: false
    }
    {
      name: rv_timer_timer_expired_hart0_timer0
      width: 1
      type: interrupt
      module_name: rv_timer
      desc: rv_timer timer_expired_hart0_timer0 interrupt
      intr_type: IntrType.Event
      default_val: false
      incoming: false
      domain: Main
      plic: rv_plic
      outgoing: false
    }
    {
      name: otp_ctrl_otp_operation_done
      width: 1
      type: interrupt
      module_name: otp_ctrl
      desc: otp_ctrl otp_operation_done interrupt
      intr_type: IntrType.Event
      default_val: false
      incoming: false
      domain: Main
      plic: rv_plic
      outgoing: false
    }
    {
      name: otp_ctrl_otp_error
      width: 1
      type: interrupt
      module_name: otp_ctrl
      desc: otp_ctrl otp_error interrupt
      intr_type: IntrType.Event
      default_val: false
      incoming: false
      domain: Main
      plic: rv_plic
      outgoing: false
    }
    {
      name: alert_handler_classa
      width: 1
      type: interrupt
      module_name: alert_handler
      desc: alert_handler classa interrupt
      intr_type: IntrType.Event
      default_val: false
      incoming: false
      domain: Main
      plic: rv_plic
      outgoing: false
    }
    {
      name: alert_handler_classb
      width: 1
      type: interrupt
      module_name: alert_handler
      desc: alert_handler classb interrupt
      intr_type: IntrType.Event
      default_val: false
      incoming: false
      domain: Main
      plic: rv_plic
      outgoing: false
    }
    {
      name: alert_handler_classc
      width: 1
      type: interrupt
      module_name: alert_handler
      desc: alert_handler classc interrupt
      intr_type: IntrType.Event
      default_val: false
      incoming: false
      domain: Main
      plic: rv_plic
      outgoing: false
    }
    {
      name: alert_handler_classd
      width: 1
      type: interrupt
      module_name: alert_handler
      desc: alert_handler classd interrupt
      intr_type: IntrType.Event
      default_val: false
      incoming: false
      domain: Main
      plic: rv_plic
      outgoing: false
    }
    {
      name: spi_host0_error
      width: 1
      type: interrupt
      module_name: spi_host0
      desc: spi_host0 error interrupt
      intr_type: IntrType.Event
      default_val: false
      incoming: false
      domain: Main
      plic: rv_plic
      outgoing: false
    }
    {
      name: spi_host0_spi_event
      width: 1
      type: interrupt
      module_name: spi_host0
      desc: spi_host0 spi_event interrupt
      intr_type: IntrType.Status
      default_val: false
      incoming: false
      domain: Main
      plic: rv_plic
      outgoing: false
    }
    {
      name: spi_host1_error
      width: 1
      type: interrupt
      module_name: spi_host1
      desc: spi_host1 error interrupt
      intr_type: IntrType.Event
      default_val: false
      incoming: false
      domain: Main
      plic: rv_plic
      outgoing: false
    }
    {
      name: spi_host1_spi_event
      width: 1
      type: interrupt
      module_name: spi_host1
      desc: spi_host1 spi_event interrupt
      intr_type: IntrType.Status
      default_val: false
      incoming: false
      domain: Main
      plic: rv_plic
      outgoing: false
    }
    {
      name: usbdev_pkt_received
      width: 1
      type: interrupt
      module_name: usbdev
      desc: usbdev pkt_received interrupt
      intr_type: IntrType.Status
      default_val: false
      incoming: false
      domain: Main
      plic: rv_plic
      outgoing: false
    }
    {
      name: usbdev_pkt_sent
      width: 1
      type: interrupt
      module_name: usbdev
      desc: usbdev pkt_sent interrupt
      intr_type: IntrType.Status
      default_val: false
      incoming: false
      domain: Main
      plic: rv_plic
      outgoing: false
    }
    {
      name: usbdev_disconnected
      width: 1
      type: interrupt
      module_name: usbdev
      desc: usbdev disconnected interrupt
      intr_type: IntrType.Event
      default_val: false
      incoming: false
      domain: Main
      plic: rv_plic
      outgoing: false
    }
    {
      name: usbdev_host_lost
      width: 1
      type: interrupt
      module_name: usbdev
      desc: usbdev host_lost interrupt
      intr_type: IntrType.Event
      default_val: false
      incoming: false
      domain: Main
      plic: rv_plic
      outgoing: false
    }
    {
      name: usbdev_link_reset
      width: 1
      type: interrupt
      module_name: usbdev
      desc: usbdev link_reset interrupt
      intr_type: IntrType.Event
      default_val: false
      incoming: false
      domain: Main
      plic: rv_plic
      outgoing: false
    }
    {
      name: usbdev_link_suspend
      width: 1
      type: interrupt
      module_name: usbdev
      desc: usbdev link_suspend interrupt
      intr_type: IntrType.Event
      default_val: false
      incoming: false
      domain: Main
      plic: rv_plic
      outgoing: false
    }
    {
      name: usbdev_link_resume
      width: 1
      type: interrupt
      module_name: usbdev
      desc: usbdev link_resume interrupt
      intr_type: IntrType.Event
      default_val: false
      incoming: false
      domain: Main
      plic: rv_plic
      outgoing: false
    }
    {
      name: usbdev_av_out_empty
      width: 1
      type: interrupt
      module_name: usbdev
      desc: usbdev av_out_empty interrupt
      intr_type: IntrType.Status
      default_val: false
      incoming: false
      domain: Main
      plic: rv_plic
      outgoing: false
    }
    {
      name: usbdev_rx_full
      width: 1
      type: interrupt
      module_name: usbdev
      desc: usbdev rx_full interrupt
      intr_type: IntrType.Status
      default_val: false
      incoming: false
      domain: Main
      plic: rv_plic
      outgoing: false
    }
    {
      name: usbdev_av_overflow
      width: 1
      type: interrupt
      module_name: usbdev
      desc: usbdev av_overflow interrupt
      intr_type: IntrType.Event
      default_val: false
      incoming: false
      domain: Main
      plic: rv_plic
      outgoing: false
    }
    {
      name: usbdev_link_in_err
      width: 1
      type: interrupt
      module_name: usbdev
      desc: usbdev link_in_err interrupt
      intr_type: IntrType.Event
      default_val: false
      incoming: false
      domain: Main
      plic: rv_plic
      outgoing: false
    }
    {
      name: usbdev_rx_crc_err
      width: 1
      type: interrupt
      module_name: usbdev
      desc: usbdev rx_crc_err interrupt
      intr_type: IntrType.Event
      default_val: false
      incoming: false
      domain: Main
      plic: rv_plic
      outgoing: false
    }
    {
      name: usbdev_rx_pid_err
      width: 1
      type: interrupt
      module_name: usbdev
      desc: usbdev rx_pid_err interrupt
      intr_type: IntrType.Event
      default_val: false
      incoming: false
      domain: Main
      plic: rv_plic
      outgoing: false
    }
    {
      name: usbdev_rx_bitstuff_err
      width: 1
      type: interrupt
      module_name: usbdev
      desc: usbdev rx_bitstuff_err interrupt
      intr_type: IntrType.Event
      default_val: false
      incoming: false
      domain: Main
      plic: rv_plic
      outgoing: false
    }
    {
      name: usbdev_frame
      width: 1
      type: interrupt
      module_name: usbdev
      desc: usbdev frame interrupt
      intr_type: IntrType.Event
      default_val: false
      incoming: false
      domain: Main
      plic: rv_plic
      outgoing: false
    }
    {
      name: usbdev_powered
      width: 1
      type: interrupt
      module_name: usbdev
      desc: usbdev powered interrupt
      intr_type: IntrType.Event
      default_val: false
      incoming: false
      domain: Main
      plic: rv_plic
      outgoing: false
    }
    {
      name: usbdev_link_out_err
      width: 1
      type: interrupt
      module_name: usbdev
      desc: usbdev link_out_err interrupt
      intr_type: IntrType.Event
      default_val: false
      incoming: false
      domain: Main
      plic: rv_plic
      outgoing: false
    }
    {
      name: usbdev_av_setup_empty
      width: 1
      type: interrupt
      module_name: usbdev
      desc: usbdev av_setup_empty interrupt
      intr_type: IntrType.Status
      default_val: false
      incoming: false
      domain: Main
      plic: rv_plic
      outgoing: false
    }
    {
      name: pwrmgr_wakeup
      width: 1
      type: interrupt
      module_name: pwrmgr
      desc: pwrmgr wakeup interrupt
      intr_type: IntrType.Event
      default_val: false
      incoming: false
      domain: Aon
      plic: rv_plic
      outgoing: false
    }
    {
      name: sysrst_ctrl_event_detected
      width: 1
      type: interrupt
      module_name: sysrst_ctrl
      desc: sysrst_ctrl event_detected interrupt
      intr_type: IntrType.Status
      default_val: false
      incoming: false
      domain: Aon
      plic: rv_plic
      outgoing: false
    }
    {
      name: adc_ctrl_match_pending
      width: 1
      type: interrupt
      module_name: adc_ctrl
      desc: adc_ctrl match_pending interrupt
      intr_type: IntrType.Status
      default_val: false
      incoming: false
      domain: Aon
      plic: rv_plic
      outgoing: false
    }
    {
      name: aon_timer_wkup_timer_expired
      width: 1
      type: interrupt
      module_name: aon_timer
      desc: aon_timer wkup_timer_expired interrupt
      intr_type: IntrType.Event
      default_val: false
      incoming: false
      domain: Aon
      plic: rv_plic
      outgoing: false
    }
    {
      name: aon_timer_wdog_timer_bark
      width: 1
      type: interrupt
      module_name: aon_timer
      desc: aon_timer wdog_timer_bark interrupt
      intr_type: IntrType.Event
      default_val: false
      incoming: false
      domain: Aon
      plic: rv_plic
      outgoing: false
    }
    {
      name: sensor_ctrl_io_status_change
      width: 1
      type: interrupt
      module_name: sensor_ctrl
      desc: sensor_ctrl io_status_change interrupt
      intr_type: IntrType.Event
      default_val: false
      incoming: false
      domain: Aon
      plic: rv_plic
      outgoing: false
    }
    {
      name: sensor_ctrl_init_status_change
      width: 1
      type: interrupt
      module_name: sensor_ctrl
      desc: sensor_ctrl init_status_change interrupt
      intr_type: IntrType.Event
      default_val: false
      incoming: false
      domain: Aon
      plic: rv_plic
      outgoing: false
    }
    {
      name: rram_ctrl_wr_empty
      width: 1
      type: interrupt
      module_name: rram_ctrl
      desc: rram_ctrl wr_empty interrupt
      intr_type: IntrType.Status
      default_val: true
      incoming: false
      domain: Main
      plic: rv_plic
      outgoing: false
    }
    {
      name: rram_ctrl_wr_lvl
      width: 1
      type: interrupt
      module_name: rram_ctrl
      desc: rram_ctrl wr_lvl interrupt
      intr_type: IntrType.Status
      default_val: true
      incoming: false
      domain: Main
      plic: rv_plic
      outgoing: false
    }
    {
      name: rram_ctrl_rd_full
      width: 1
      type: interrupt
      module_name: rram_ctrl
      desc: rram_ctrl rd_full interrupt
      intr_type: IntrType.Status
      default_val: false
      incoming: false
      domain: Main
      plic: rv_plic
      outgoing: false
    }
    {
      name: rram_ctrl_rd_lvl
      width: 1
      type: interrupt
      module_name: rram_ctrl
      desc: rram_ctrl rd_lvl interrupt
      intr_type: IntrType.Status
      default_val: false
      incoming: false
      domain: Main
      plic: rv_plic
      outgoing: false
    }
    {
      name: rram_ctrl_op_done
      width: 1
      type: interrupt
      module_name: rram_ctrl
      desc: rram_ctrl op_done interrupt
      intr_type: IntrType.Event
      default_val: false
      incoming: false
      domain: Main
      plic: rv_plic
      outgoing: false
    }
    {
      name: rram_ctrl_corr1_err
      width: 1
      type: interrupt
      module_name: rram_ctrl
      desc: rram_ctrl corr1_err interrupt
      intr_type: IntrType.Event
      default_val: false
      incoming: false
      domain: Main
      plic: rv_plic
      outgoing: false
    }
    {
      name: rram_ctrl_corr2_err
      width: 1
      type: interrupt
      module_name: rram_ctrl
      desc: rram_ctrl corr2_err interrupt
      intr_type: IntrType.Event
      default_val: false
      incoming: false
      domain: Main
      plic: rv_plic
      outgoing: false
    }
    {
      name: hmac_hmac_done
      width: 1
      type: interrupt
      module_name: hmac
      desc: hmac hmac_done interrupt
      intr_type: IntrType.Event
      default_val: false
      incoming: false
      domain: Main
      plic: rv_plic
      outgoing: false
    }
    {
      name: hmac_fifo_empty
      width: 1
      type: interrupt
      module_name: hmac
      desc: hmac fifo_empty interrupt
      intr_type: IntrType.Status
      default_val: false
      incoming: false
      domain: Main
      plic: rv_plic
      outgoing: false
    }
    {
      name: hmac_hmac_err
      width: 1
      type: interrupt
      module_name: hmac
      desc: hmac hmac_err interrupt
      intr_type: IntrType.Event
      default_val: false
      incoming: false
      domain: Main
      plic: rv_plic
      outgoing: false
    }
    {
      name: kmac_kmac_done
      width: 1
      type: interrupt
      module_name: kmac
      desc: kmac kmac_done interrupt
      intr_type: IntrType.Event
      default_val: false
      incoming: false
      domain: Main
      plic: rv_plic
      outgoing: false
    }
    {
      name: kmac_fifo_empty
      width: 1
      type: interrupt
      module_name: kmac
      desc: kmac fifo_empty interrupt
      intr_type: IntrType.Status
      default_val: false
      incoming: false
      domain: Main
      plic: rv_plic
      outgoing: false
    }
    {
      name: kmac_kmac_err
      width: 1
      type: interrupt
      module_name: kmac
      desc: kmac kmac_err interrupt
      intr_type: IntrType.Event
      default_val: false
      incoming: false
      domain: Main
      plic: rv_plic
      outgoing: false
    }
    {
      name: otbn_done
      width: 1
      type: interrupt
      module_name: otbn
      desc: otbn done interrupt
      intr_type: IntrType.Event
      default_val: false
      incoming: false
      domain: Main
      plic: rv_plic
      outgoing: false
    }
    {
      name: keymgr_dpe_op_done
      width: 1
      type: interrupt
      module_name: keymgr_dpe
      desc: keymgr_dpe op_done interrupt
      intr_type: IntrType.Event
      default_val: false
      incoming: false
      domain: Main
      plic: rv_plic
      outgoing: false
    }
    {
      name: csrng_cs_cmd_req_done
      width: 1
      type: interrupt
      module_name: csrng
      desc: csrng cs_cmd_req_done interrupt
      intr_type: IntrType.Event
      default_val: false
      incoming: false
      domain: Main
      plic: rv_plic
      outgoing: false
    }
    {
      name: csrng_cs_entropy_req
      width: 1
      type: interrupt
      module_name: csrng
      desc: csrng cs_entropy_req interrupt
      intr_type: IntrType.Event
      default_val: false
      incoming: false
      domain: Main
      plic: rv_plic
      outgoing: false
    }
    {
      name: csrng_cs_hw_inst_exc
      width: 1
      type: interrupt
      module_name: csrng
      desc: csrng cs_hw_inst_exc interrupt
      intr_type: IntrType.Event
      default_val: false
      incoming: false
      domain: Main
      plic: rv_plic
      outgoing: false
    }
    {
      name: csrng_cs_fatal_err
      width: 1
      type: interrupt
      module_name: csrng
      desc: csrng cs_fatal_err interrupt
      intr_type: IntrType.Event
      default_val: false
      incoming: false
      domain: Main
      plic: rv_plic
      outgoing: false
    }
    {
      name: entropy_src_es_entropy_valid
      width: 1
      type: interrupt
      module_name: entropy_src
      desc: entropy_src es_entropy_valid interrupt
      intr_type: IntrType.Event
      default_val: false
      incoming: false
      domain: Main
      plic: rv_plic
      outgoing: false
    }
    {
      name: entropy_src_es_health_test_failed
      width: 1
      type: interrupt
      module_name: entropy_src
      desc: entropy_src es_health_test_failed interrupt
      intr_type: IntrType.Event
      default_val: false
      incoming: false
      domain: Main
      plic: rv_plic
      outgoing: false
    }
    {
      name: entropy_src_es_observe_fifo_ready
      width: 1
      type: interrupt
      module_name: entropy_src
      desc: entropy_src es_observe_fifo_ready interrupt
      intr_type: IntrType.Event
      default_val: false
      incoming: false
      domain: Main
      plic: rv_plic
      outgoing: false
    }
    {
      name: entropy_src_es_fatal_err
      width: 1
      type: interrupt
      module_name: entropy_src
      desc: entropy_src es_fatal_err interrupt
      intr_type: IntrType.Event
      default_val: false
      incoming: false
      domain: Main
      plic: rv_plic
      outgoing: false
    }
    {
      name: edn0_edn_cmd_req_done
      width: 1
      type: interrupt
      module_name: edn0
      desc: edn0 edn_cmd_req_done interrupt
      intr_type: IntrType.Event
      default_val: false
      incoming: false
      domain: Main
      plic: rv_plic
      outgoing: false
    }
    {
      name: edn0_edn_fatal_err
      width: 1
      type: interrupt
      module_name: edn0
      desc: edn0 edn_fatal_err interrupt
      intr_type: IntrType.Event
      default_val: false
      incoming: false
      domain: Main
      plic: rv_plic
      outgoing: false
    }
    {
      name: edn1_edn_cmd_req_done
      width: 1
      type: interrupt
      module_name: edn1
      desc: edn1 edn_cmd_req_done interrupt
      intr_type: IntrType.Event
      default_val: false
      incoming: false
      domain: Main
      plic: rv_plic
      outgoing: false
    }
    {
      name: edn1_edn_fatal_err
      width: 1
      type: interrupt
      module_name: edn1
      desc: edn1 edn_fatal_err interrupt
      intr_type: IntrType.Event
      default_val: false
      incoming: false
      domain: Main
      plic: rv_plic
      outgoing: false
    }
    {
      name: cheriot_mem_sys_tbre_done
      width: 1
      type: interrupt
      module_name: cheriot_mem_sys
      desc: cheriot_mem_sys tbre_done interrupt
      intr_type: IntrType.Event
      default_val: false
      incoming: false
      domain: Main
      plic: rv_plic
      outgoing: false
    }
  ]
  outgoing_interrupt: {}
  plic_info:
  {
    rv_plic:
    {
      domain: Main
      count_tot: 222
      count_pd:
      {
        Aon: 7
        Main: 214
      }
    }
  }
  inter_pd:
  {
    definitions:
    [
      {
        package: ""
        struct: logic
        domain: chip
        signame: intr_vector_pd_aon
        width: 7
        type: uni
        special: interrupt
        end_idx: -1
        act: req
        suffix: ""
        default: "'0"
      }
      {
        package: prim_alert_pkg
        struct: alert_tx
        domain: chip
        signame: alert_tx_pd_aon
        width: 12
        type: uni
        special: alert
        end_idx: -1
        act: req
        suffix: ""
        default: "'0"
      }
      {
        package: prim_alert_pkg
        struct: alert_rx
        domain: chip
        signame: alert_rx_pd_aon
        width: 12
        type: uni
        special: alert
        end_idx: -1
        act: req
        suffix: ""
        default: "'0"
      }
      {
        package: ast_pkg
        struct: ast_obs_ctrl
        domain: chip
        signame: ast_obs_ctrl
        width: 1
        type: uni
        end_idx: -1
        act: req
        suffix: ""
        default: ast_pkg::AST_OBS_CTRL_DEFAULT
      }
      {
        package: prim_mubi_pkg
        struct: mubi4
        domain: chip
        signame: ast_clk_src_sys_jen
        width: 1
        type: uni
        end_idx: -1
        act: rcv
        suffix: ""
        default: prim_mubi_pkg::MUBI4_DEFAULT
      }
      {
        package: prim_mubi_pkg
        struct: mubi4
        domain: chip
        signame: ast_init_done
        width: 1
        type: uni
        end_idx: -1
        act: req
        suffix: ""
        default: prim_mubi_pkg::MUBI4_DEFAULT
      }
      {
        package: prim_mubi_pkg
        struct: mubi4
        domain: chip
        signame: clkmgr_all_clk_byp_req
        width: 1
        type: uni
        end_idx: -1
        act: req
        suffix: ""
        default: prim_mubi_pkg::MUBI4_DEFAULT
      }
      {
        package: prim_mubi_pkg
        struct: mubi4
        domain: chip
        signame: clkmgr_all_clk_byp_ack
        width: 1
        type: uni
        end_idx: -1
        act: rcv
        suffix: ""
        default: prim_mubi_pkg::MUBI4_DEFAULT
      }
      {
        package: prim_mubi_pkg
        struct: mubi4
        domain: chip
        signame: clkmgr_io_clk_byp_req
        width: 1
        type: uni
        end_idx: -1
        act: req
        suffix: ""
        default: prim_mubi_pkg::MUBI4_DEFAULT
      }
      {
        package: prim_mubi_pkg
        struct: mubi4
        domain: chip
        signame: clkmgr_io_clk_byp_ack
        width: 1
        type: uni
        end_idx: -1
        act: rcv
        suffix: ""
        default: prim_mubi_pkg::MUBI4_DEFAULT
      }
      {
        package: prim_mubi_pkg
        struct: mubi4
        domain: chip
        signame: clkmgr_hi_speed_sel
        width: 1
        type: uni
        end_idx: -1
        act: req
        suffix: ""
        default: prim_mubi_pkg::MUBI4_DEFAULT
      }
      {
        package: prim_mubi_pkg
        struct: mubi4
        domain: chip
        signame: clkmgr_div_step_down_req
        width: 1
        type: uni
        end_idx: -1
        act: rcv
        suffix: ""
        default: prim_mubi_pkg::MUBI4_DEFAULT
      }
      {
        package: alert_handler_pkg
        struct: alert_crashdump
        domain: chip
        signame: alert_handler_crashdump
        width: 1
        type: uni
        end_idx: -1
        act: req
        suffix: ""
        default: alert_handler_pkg::ALERT_CRASHDUMP_DEFAULT
      }
      {
        package: prim_esc_pkg
        struct: esc_rx
        domain: chip
        signame: alert_handler_esc_rx
        width: 1
        type: uni
        end_idx: -1
        act: rcv
        suffix: ""
        default: "'{default: prim_esc_pkg::ESC_RX_DEFAULT}"
      }
      {
        package: prim_esc_pkg
        struct: esc_tx
        domain: chip
        signame: alert_handler_esc_tx
        width: 1
        type: uni
        end_idx: -1
        act: req
        suffix: ""
        default: "'{default: prim_esc_pkg::ESC_TX_DEFAULT}"
      }
      {
        package: ""
        struct: logic
        domain: chip
        signame: aon_timer_nmi_wdog_timer_bark
        width: 1
        type: uni
        end_idx: -1
        act: req
        suffix: ""
        default: 1'b0
      }
      {
        package: otp_ctrl_pkg
        struct: sram_otp_key_req
        domain: chip
        signame: otp_ctrl_sram_otp_key_req
        width: 1
        type: req_rsp
        end_idx: -1
        act: rsp
        suffix: req
        default: "'0"
      }
      {
        package: otp_ctrl_pkg
        struct: sram_otp_key_rsp
        domain: chip
        signame: otp_ctrl_sram_otp_key_rsp
        width: 1
        type: req_rsp
        end_idx: -1
        act: rsp
        suffix: rsp
        default: "'0"
      }
      {
        package: pwrmgr_pkg
        struct: pwr_nvm
        domain: chip
        signame: pwrmgr_pwr_nvm
        width: 1
        type: uni
        end_idx: -1
        act: rcv
        suffix: ""
        default: pwrmgr_pkg::PWR_NVM_DEFAULT
      }
      {
        package: pwrmgr_pkg
        struct: pwr_otp_req
        domain: chip
        signame: pwrmgr_pwr_otp_req
        width: 1
        type: req_rsp
        end_idx: -1
        act: req
        suffix: req
        default: pwrmgr_pkg::PWR_OTP_REQ_DEFAULT
      }
      {
        package: pwrmgr_pkg
        struct: pwr_otp_rsp
        domain: chip
        signame: pwrmgr_pwr_otp_rsp
        width: 1
        type: req_rsp
        end_idx: -1
        act: req
        suffix: rsp
        default: pwrmgr_pkg::PWR_OTP_RSP_DEFAULT
      }
      {
        package: lc_ctrl_pkg
        struct: pwr_lc_req
        domain: chip
        signame: pwrmgr_pwr_lc_req
        width: 1
        type: req_rsp
        end_idx: -1
        act: req
        suffix: req
        default: lc_ctrl_pkg::PWR_LC_REQ_DEFAULT
      }
      {
        package: lc_ctrl_pkg
        struct: pwr_lc_rsp
        domain: chip
        signame: pwrmgr_pwr_lc_rsp
        width: 1
        type: req_rsp
        end_idx: -1
        act: req
        suffix: rsp
        default: lc_ctrl_pkg::PWR_LC_RSP_DEFAULT
      }
      {
        package: lc_ctrl_pkg
        struct: lc_tx
        domain: chip
        signame: pwrmgr_fetch_en
        width: 1
        type: uni
        end_idx: -1
        act: req
        suffix: ""
        default: lc_ctrl_pkg::LC_TX_DEFAULT
      }
      {
        package: rom_ctrl_pkg
        struct: pwrmgr_data
        domain: chip
        signame: rom_ctrl_pwrmgr_data
        width: 1
        type: uni
        end_idx: -1
        act: req
        suffix: ""
        default: rom_ctrl_pkg::PWRMGR_DATA_DEFAULT
      }
      {
        package: ""
        struct: logic
        domain: chip
        signame: usbdev_usb_dp_pullup
        width: 1
        type: uni
        end_idx: -1
        act: req
        suffix: ""
        default: 1'b0
      }
      {
        package: ""
        struct: logic
        domain: chip
        signame: usbdev_usb_dn_pullup
        width: 1
        type: uni
        end_idx: -1
        act: req
        suffix: ""
        default: 1'b0
      }
      {
        package: ""
        struct: logic
        domain: chip
        signame: usbdev_usb_aon_suspend_req
        width: 1
        type: uni
        end_idx: -1
        act: req
        suffix: ""
        default: 1'b0
      }
      {
        package: ""
        struct: logic
        domain: chip
        signame: usbdev_usb_aon_wake_ack
        width: 1
        type: uni
        end_idx: -1
        act: req
        suffix: ""
        default: 1'b0
      }
      {
        package: ""
        struct: logic
        domain: chip
        signame: usbdev_usb_aon_bus_not_idle
        width: 1
        type: uni
        end_idx: -1
        act: rcv
        suffix: ""
        default: 1'b0
      }
      {
        package: ""
        struct: logic
        domain: chip
        signame: usbdev_usb_aon_bus_reset
        width: 1
        type: uni
        end_idx: -1
        act: rcv
        suffix: ""
        default: 1'b0
      }
      {
        package: ""
        struct: logic
        domain: chip
        signame: usbdev_usb_aon_sense_lost
        width: 1
        type: uni
        end_idx: -1
        act: rcv
        suffix: ""
        default: 1'b0
      }
      {
        package: ""
        struct: logic
        domain: chip
        signame: pinmux_usbdev_wake_detect_active
        width: 1
        type: uni
        end_idx: -1
        act: req
        suffix: ""
        default: 1'b0
      }
      {
        package: prim_mubi_pkg
        struct: mubi4
        domain: chip
        signame: clkmgr_idle
        width: 4
        type: uni
        end_idx: -1
        act: rcv
        suffix: ""
        default: "'{default: prim_mubi_pkg::MUBI4_DEFAULT}"
      }
      {
        package: jtag_pkg
        struct: jtag_req
        domain: chip
        signame: pinmux_lc_jtag_req
        width: 1
        type: req_rsp
        end_idx: -1
        act: req
        suffix: req
        default: jtag_pkg::JTAG_REQ_DEFAULT
      }
      {
        package: jtag_pkg
        struct: jtag_rsp
        domain: chip
        signame: pinmux_lc_jtag_rsp
        width: 1
        type: req_rsp
        end_idx: -1
        act: req
        suffix: rsp
        default: jtag_pkg::JTAG_RSP_DEFAULT
      }
      {
        package: jtag_pkg
        struct: jtag_req
        domain: chip
        signame: pinmux_rv_jtag_req
        width: 1
        type: req_rsp
        end_idx: -1
        act: req
        suffix: req
        default: jtag_pkg::JTAG_REQ_DEFAULT
      }
      {
        package: jtag_pkg
        struct: jtag_rsp
        domain: chip
        signame: pinmux_rv_jtag_rsp
        width: 1
        type: req_rsp
        end_idx: -1
        act: req
        suffix: rsp
        default: jtag_pkg::JTAG_RSP_DEFAULT
      }
      {
        package: jtag_pkg
        struct: jtag_req
        domain: chip
        signame: pinmux_rram_jtag_req
        width: 1
        type: req_rsp
        end_idx: -1
        act: req
        suffix: req
        default: jtag_pkg::JTAG_REQ_DEFAULT
      }
      {
        package: jtag_pkg
        struct: jtag_rsp
        domain: chip
        signame: pinmux_rram_jtag_rsp
        width: 1
        type: req_rsp
        end_idx: -1
        act: req
        suffix: rsp
        default: jtag_pkg::JTAG_RSP_DEFAULT
      }
      {
        package: lc_ctrl_pkg
        struct: lc_tx
        domain: chip
        signame: pinmux_pinmux_hw_debug_en
        width: 1
        type: uni
        end_idx: -1
        act: req
        suffix: ""
        default: lc_ctrl_pkg::Off
      }
      {
        package: ""
        struct: logic
        domain: chip
        signame: lc_ctrl_strap_en_override
        width: 1
        type: uni
        end_idx: -1
        act: req
        suffix: ""
        default: 1'b0
      }
      {
        package: lc_ctrl_pkg
        struct: lc_tx
        domain: chip
        signame: lc_ctrl_lc_dft_en
        width: 1
        type: uni
        end_idx: -1
        act: req
        suffix: ""
        default: lc_ctrl_pkg::Off
      }
      {
        package: lc_ctrl_pkg
        struct: lc_tx
        domain: chip
        signame: lc_ctrl_lc_nvm_debug_en
        width: 1
        type: uni
        end_idx: -1
        act: req
        suffix: ""
        default: lc_ctrl_pkg::Off
      }
      {
        package: lc_ctrl_pkg
        struct: lc_tx
        domain: chip
        signame: lc_ctrl_lc_hw_debug_clr
        width: 1
        type: uni
        end_idx: -1
        act: req
        suffix: ""
        default: lc_ctrl_pkg::Off
      }
      {
        package: lc_ctrl_pkg
        struct: lc_tx
        domain: chip
        signame: lc_ctrl_lc_hw_debug_en
        width: 1
        type: uni
        end_idx: -1
        act: req
        suffix: ""
        default: lc_ctrl_pkg::Off
      }
      {
        package: lc_ctrl_pkg
        struct: lc_tx
        domain: chip
        signame: lc_ctrl_lc_escalate_en
        width: 1
        type: uni
        end_idx: -1
        act: req
        suffix: ""
        default: lc_ctrl_pkg::Off
      }
      {
        package: lc_ctrl_pkg
        struct: lc_tx
        domain: chip
        signame: lc_ctrl_lc_check_byp_en
        width: 1
        type: uni
        end_idx: -1
        act: req
        suffix: ""
        default: lc_ctrl_pkg::Off
      }
      {
        package: lc_ctrl_pkg
        struct: lc_tx
        domain: chip
        signame: lc_ctrl_lc_clk_byp_req
        width: 1
        type: uni
        end_idx: -1
        act: req
        suffix: ""
        default: lc_ctrl_pkg::Off
      }
      {
        package: lc_ctrl_pkg
        struct: lc_tx
        domain: chip
        signame: lc_ctrl_lc_clk_byp_ack
        width: 1
        type: uni
        end_idx: -1
        act: rcv
        suffix: ""
        default: lc_ctrl_pkg::Off
      }
      {
        package: rv_core_ibex_pkg
        struct: cpu_crash_dump
        domain: chip
        signame: rv_core_ibex_crash_dump
        width: 1
        type: uni
        end_idx: -1
        act: req
        suffix: ""
        default: rv_core_ibex_pkg::CPU_CRASH_DUMP_DEFAULT
      }
      {
        package: rv_core_ibex_pkg
        struct: cpu_pwrmgr
        domain: chip
        signame: rv_core_ibex_pwrmgr
        width: 1
        type: uni
        end_idx: -1
        act: req
        suffix: ""
        default: rv_core_ibex_pkg::CPU_PWRMGR_DEFAULT
      }
      {
        package: ""
        struct: logic
        domain: chip
        signame: rv_dm_ndmreset_req
        width: 1
        type: uni
        end_idx: -1
        act: req
        suffix: ""
        default: 1'b0
      }
      {
        package: ""
        struct: logic
        domain: chip
        signame: pwrmgr_wakeups
        width: 1
        type: uni
        end_idx: -1
        act: rcv
        suffix: ""
        default: "'0"
      }
      {
        package: ""
        struct: logic
        domain: chip
        signame: i3c0_rstdet_enable
        width: 1
        type: uni
        end_idx: -1
        act: req
        suffix: ""
        default: 1'b0
      }
      {
        package: i3c_pkg
        struct: i3c_rstdet_req
        domain: chip
        signame: i3c0_rstdet_req
        width: 1
        type: req_rsp
        end_idx: -1
        act: req
        suffix: req
        default: i3c_pkg::I3C_RSTDET_REQ_DEFAULT
      }
      {
        package: i3c_pkg
        struct: i3c_rstdet_rsp
        domain: chip
        signame: i3c0_rstdet_rsp
        width: 1
        type: req_rsp
        end_idx: -1
        act: req
        suffix: rsp
        default: i3c_pkg::I3C_RSTDET_RSP_DEFAULT
      }
      {
        package: ast_intraip_pkg
        struct: s2p
        domain: chip
        signame: ast_intraip_s2p
        width: 1
        type: uni
        end_idx: -1
        act: req
        suffix: ""
        default: ast_intraip_pkg::S2P_DEFAULT
      }
      {
        package: ast_intraip_pkg
        struct: p2s
        domain: chip
        signame: ast_intraip_p2s
        width: 1
        type: uni
        end_idx: -1
        act: req
        suffix: ""
        default: ast_intraip_pkg::P2S_DEFAULT
      }
      {
        package: tlul_pkg
        struct: tl_h2d
        domain: chip
        signame: pwrmgr_tl_req
        width: 1
        type: req_rsp
        end_idx: -1
        act: rsp
        suffix: req
        default: tlul_pkg::TL_H2D_DEFAULT
      }
      {
        package: tlul_pkg
        struct: tl_d2h
        domain: chip
        signame: pwrmgr_tl_rsp
        width: 1
        type: req_rsp
        end_idx: -1
        act: rsp
        suffix: rsp
        default: tlul_pkg::TL_D2H_DEFAULT
      }
      {
        package: tlul_pkg
        struct: tl_h2d
        domain: chip
        signame: rstmgr_tl_req
        width: 1
        type: req_rsp
        end_idx: -1
        act: rsp
        suffix: req
        default: tlul_pkg::TL_H2D_DEFAULT
      }
      {
        package: tlul_pkg
        struct: tl_d2h
        domain: chip
        signame: rstmgr_tl_rsp
        width: 1
        type: req_rsp
        end_idx: -1
        act: rsp
        suffix: rsp
        default: tlul_pkg::TL_D2H_DEFAULT
      }
      {
        package: tlul_pkg
        struct: tl_h2d
        domain: chip
        signame: clkmgr_tl_req
        width: 1
        type: req_rsp
        end_idx: -1
        act: rsp
        suffix: req
        default: tlul_pkg::TL_H2D_DEFAULT
      }
      {
        package: tlul_pkg
        struct: tl_d2h
        domain: chip
        signame: clkmgr_tl_rsp
        width: 1
        type: req_rsp
        end_idx: -1
        act: rsp
        suffix: rsp
        default: tlul_pkg::TL_D2H_DEFAULT
      }
      {
        package: tlul_pkg
        struct: tl_h2d
        domain: chip
        signame: pinmux_tl_req
        width: 1
        type: req_rsp
        end_idx: -1
        act: rsp
        suffix: req
        default: tlul_pkg::TL_H2D_DEFAULT
      }
      {
        package: tlul_pkg
        struct: tl_d2h
        domain: chip
        signame: pinmux_tl_rsp
        width: 1
        type: req_rsp
        end_idx: -1
        act: rsp
        suffix: rsp
        default: tlul_pkg::TL_D2H_DEFAULT
      }
      {
        package: tlul_pkg
        struct: tl_h2d
        domain: chip
        signame: sensor_ctrl_tl_req
        width: 1
        type: req_rsp
        end_idx: -1
        act: rsp
        suffix: req
        default: tlul_pkg::TL_H2D_DEFAULT
      }
      {
        package: tlul_pkg
        struct: tl_d2h
        domain: chip
        signame: sensor_ctrl_tl_rsp
        width: 1
        type: req_rsp
        end_idx: -1
        act: rsp
        suffix: rsp
        default: tlul_pkg::TL_D2H_DEFAULT
      }
      {
        package: tlul_pkg
        struct: tl_h2d
        domain: chip
        signame: sram_ctrl_ret_regs_tl_req
        width: 1
        type: req_rsp
        end_idx: -1
        act: rsp
        suffix: req
        default: tlul_pkg::TL_H2D_DEFAULT
      }
      {
        package: tlul_pkg
        struct: tl_d2h
        domain: chip
        signame: sram_ctrl_ret_regs_tl_rsp
        width: 1
        type: req_rsp
        end_idx: -1
        act: rsp
        suffix: rsp
        default: tlul_pkg::TL_D2H_DEFAULT
      }
      {
        package: tlul_pkg
        struct: tl_h2d
        domain: chip
        signame: sram_ctrl_ret_ram_tl_req
        width: 1
        type: req_rsp
        end_idx: -1
        act: rsp
        suffix: req
        default: tlul_pkg::TL_H2D_DEFAULT
      }
      {
        package: tlul_pkg
        struct: tl_d2h
        domain: chip
        signame: sram_ctrl_ret_ram_tl_rsp
        width: 1
        type: req_rsp
        end_idx: -1
        act: rsp
        suffix: rsp
        default: tlul_pkg::TL_D2H_DEFAULT
      }
      {
        package: tlul_pkg
        struct: tl_h2d
        domain: chip
        signame: aon_timer_tl_req
        width: 1
        type: req_rsp
        end_idx: -1
        act: rsp
        suffix: req
        default: tlul_pkg::TL_H2D_DEFAULT
      }
      {
        package: tlul_pkg
        struct: tl_d2h
        domain: chip
        signame: aon_timer_tl_rsp
        width: 1
        type: req_rsp
        end_idx: -1
        act: rsp
        suffix: rsp
        default: tlul_pkg::TL_D2H_DEFAULT
      }
      {
        package: tlul_pkg
        struct: tl_h2d
        domain: chip
        signame: sysrst_ctrl_tl_req
        width: 1
        type: req_rsp
        end_idx: -1
        act: rsp
        suffix: req
        default: tlul_pkg::TL_H2D_DEFAULT
      }
      {
        package: tlul_pkg
        struct: tl_d2h
        domain: chip
        signame: sysrst_ctrl_tl_rsp
        width: 1
        type: req_rsp
        end_idx: -1
        act: rsp
        suffix: rsp
        default: tlul_pkg::TL_D2H_DEFAULT
      }
      {
        package: tlul_pkg
        struct: tl_h2d
        domain: chip
        signame: adc_ctrl_tl_req
        width: 1
        type: req_rsp
        end_idx: -1
        act: rsp
        suffix: req
        default: tlul_pkg::TL_H2D_DEFAULT
      }
      {
        package: tlul_pkg
        struct: tl_d2h
        domain: chip
        signame: adc_ctrl_tl_rsp
        width: 1
        type: req_rsp
        end_idx: -1
        act: rsp
        suffix: rsp
        default: tlul_pkg::TL_D2H_DEFAULT
      }
      {
        package: ""
        struct: logic
        domain: chip
        signame: cio_uart0_rx_p2d
        width: 1
        type: uni
        end_idx: -1
        act: ""
        suffix: ""
        default: "'0"
      }
      {
        package: ""
        struct: logic
        domain: chip
        signame: cio_uart0_tx_d2p
        width: 1
        type: uni
        end_idx: -1
        act: ""
        suffix: ""
        default: "'0"
      }
      {
        package: ""
        struct: logic
        domain: chip
        signame: cio_uart0_tx_en_d2p
        width: 1
        type: uni
        end_idx: -1
        act: ""
        suffix: ""
        default: "'0"
      }
      {
        package: ""
        struct: logic
        domain: chip
        signame: cio_uart1_rx_p2d
        width: 1
        type: uni
        end_idx: -1
        act: ""
        suffix: ""
        default: "'0"
      }
      {
        package: ""
        struct: logic
        domain: chip
        signame: cio_uart1_tx_d2p
        width: 1
        type: uni
        end_idx: -1
        act: ""
        suffix: ""
        default: "'0"
      }
      {
        package: ""
        struct: logic
        domain: chip
        signame: cio_uart1_tx_en_d2p
        width: 1
        type: uni
        end_idx: -1
        act: ""
        suffix: ""
        default: "'0"
      }
      {
        package: ""
        struct: logic
        domain: chip
        signame: cio_uart2_rx_p2d
        width: 1
        type: uni
        end_idx: -1
        act: ""
        suffix: ""
        default: "'0"
      }
      {
        package: ""
        struct: logic
        domain: chip
        signame: cio_uart2_tx_d2p
        width: 1
        type: uni
        end_idx: -1
        act: ""
        suffix: ""
        default: "'0"
      }
      {
        package: ""
        struct: logic
        domain: chip
        signame: cio_uart2_tx_en_d2p
        width: 1
        type: uni
        end_idx: -1
        act: ""
        suffix: ""
        default: "'0"
      }
      {
        package: ""
        struct: logic
        domain: chip
        signame: cio_uart3_rx_p2d
        width: 1
        type: uni
        end_idx: -1
        act: ""
        suffix: ""
        default: "'0"
      }
      {
        package: ""
        struct: logic
        domain: chip
        signame: cio_uart3_tx_d2p
        width: 1
        type: uni
        end_idx: -1
        act: ""
        suffix: ""
        default: "'0"
      }
      {
        package: ""
        struct: logic
        domain: chip
        signame: cio_uart3_tx_en_d2p
        width: 1
        type: uni
        end_idx: -1
        act: ""
        suffix: ""
        default: "'0"
      }
      {
        package: ""
        struct: logic
        domain: chip
        signame: cio_gpio0_gpio_d2p
        width: 32
        type: uni
        end_idx: -1
        act: ""
        suffix: ""
        default: "'0"
      }
      {
        package: ""
        struct: logic
        domain: chip
        signame: cio_gpio0_gpio_en_d2p
        width: 32
        type: uni
        end_idx: -1
        act: ""
        suffix: ""
        default: "'0"
      }
      {
        package: ""
        struct: logic
        domain: chip
        signame: cio_gpio0_gpio_p2d
        width: 32
        type: uni
        end_idx: -1
        act: ""
        suffix: ""
        default: "'0"
      }
      {
        package: ""
        struct: logic
        domain: chip
        signame: cio_gpio1_gpio_d2p
        width: 32
        type: uni
        end_idx: -1
        act: ""
        suffix: ""
        default: "'0"
      }
      {
        package: ""
        struct: logic
        domain: chip
        signame: cio_gpio1_gpio_en_d2p
        width: 32
        type: uni
        end_idx: -1
        act: ""
        suffix: ""
        default: "'0"
      }
      {
        package: ""
        struct: logic
        domain: chip
        signame: cio_gpio1_gpio_p2d
        width: 32
        type: uni
        end_idx: -1
        act: ""
        suffix: ""
        default: "'0"
      }
      {
        package: ""
        struct: logic
        domain: chip
        signame: cio_spi_device_sd_d2p
        width: 4
        type: uni
        end_idx: -1
        act: ""
        suffix: ""
        default: "'0"
      }
      {
        package: ""
        struct: logic
        domain: chip
        signame: cio_spi_device_sd_en_d2p
        width: 4
        type: uni
        end_idx: -1
        act: ""
        suffix: ""
        default: "'0"
      }
      {
        package: ""
        struct: logic
        domain: chip
        signame: cio_spi_device_sd_p2d
        width: 4
        type: uni
        end_idx: -1
        act: ""
        suffix: ""
        default: "'0"
      }
      {
        package: ""
        struct: logic
        domain: chip
        signame: cio_spi_device_sck_p2d
        width: 1
        type: uni
        end_idx: -1
        act: ""
        suffix: ""
        default: "'0"
      }
      {
        package: ""
        struct: logic
        domain: chip
        signame: cio_spi_device_csb_p2d
        width: 1
        type: uni
        end_idx: -1
        act: ""
        suffix: ""
        default: "'0"
      }
      {
        package: ""
        struct: logic
        domain: chip
        signame: cio_spi_device_tpm_csb_p2d
        width: 1
        type: uni
        end_idx: -1
        act: ""
        suffix: ""
        default: "'0"
      }
      {
        package: ""
        struct: logic
        domain: chip
        signame: cio_i2c0_sda_d2p
        width: 1
        type: uni
        end_idx: -1
        act: ""
        suffix: ""
        default: "'0"
      }
      {
        package: ""
        struct: logic
        domain: chip
        signame: cio_i2c0_sda_en_d2p
        width: 1
        type: uni
        end_idx: -1
        act: ""
        suffix: ""
        default: "'0"
      }
      {
        package: ""
        struct: logic
        domain: chip
        signame: cio_i2c0_sda_p2d
        width: 1
        type: uni
        end_idx: -1
        act: ""
        suffix: ""
        default: "'0"
      }
      {
        package: ""
        struct: logic
        domain: chip
        signame: cio_i2c0_scl_d2p
        width: 1
        type: uni
        end_idx: -1
        act: ""
        suffix: ""
        default: "'0"
      }
      {
        package: ""
        struct: logic
        domain: chip
        signame: cio_i2c0_scl_en_d2p
        width: 1
        type: uni
        end_idx: -1
        act: ""
        suffix: ""
        default: "'0"
      }
      {
        package: ""
        struct: logic
        domain: chip
        signame: cio_i2c0_scl_p2d
        width: 1
        type: uni
        end_idx: -1
        act: ""
        suffix: ""
        default: "'0"
      }
      {
        package: ""
        struct: logic
        domain: chip
        signame: cio_i2c1_sda_d2p
        width: 1
        type: uni
        end_idx: -1
        act: ""
        suffix: ""
        default: "'0"
      }
      {
        package: ""
        struct: logic
        domain: chip
        signame: cio_i2c1_sda_en_d2p
        width: 1
        type: uni
        end_idx: -1
        act: ""
        suffix: ""
        default: "'0"
      }
      {
        package: ""
        struct: logic
        domain: chip
        signame: cio_i2c1_sda_p2d
        width: 1
        type: uni
        end_idx: -1
        act: ""
        suffix: ""
        default: "'0"
      }
      {
        package: ""
        struct: logic
        domain: chip
        signame: cio_i2c1_scl_d2p
        width: 1
        type: uni
        end_idx: -1
        act: ""
        suffix: ""
        default: "'0"
      }
      {
        package: ""
        struct: logic
        domain: chip
        signame: cio_i2c1_scl_en_d2p
        width: 1
        type: uni
        end_idx: -1
        act: ""
        suffix: ""
        default: "'0"
      }
      {
        package: ""
        struct: logic
        domain: chip
        signame: cio_i2c1_scl_p2d
        width: 1
        type: uni
        end_idx: -1
        act: ""
        suffix: ""
        default: "'0"
      }
      {
        package: ""
        struct: logic
        domain: chip
        signame: cio_i2c2_sda_d2p
        width: 1
        type: uni
        end_idx: -1
        act: ""
        suffix: ""
        default: "'0"
      }
      {
        package: ""
        struct: logic
        domain: chip
        signame: cio_i2c2_sda_en_d2p
        width: 1
        type: uni
        end_idx: -1
        act: ""
        suffix: ""
        default: "'0"
      }
      {
        package: ""
        struct: logic
        domain: chip
        signame: cio_i2c2_sda_p2d
        width: 1
        type: uni
        end_idx: -1
        act: ""
        suffix: ""
        default: "'0"
      }
      {
        package: ""
        struct: logic
        domain: chip
        signame: cio_i2c2_scl_d2p
        width: 1
        type: uni
        end_idx: -1
        act: ""
        suffix: ""
        default: "'0"
      }
      {
        package: ""
        struct: logic
        domain: chip
        signame: cio_i2c2_scl_en_d2p
        width: 1
        type: uni
        end_idx: -1
        act: ""
        suffix: ""
        default: "'0"
      }
      {
        package: ""
        struct: logic
        domain: chip
        signame: cio_i2c2_scl_p2d
        width: 1
        type: uni
        end_idx: -1
        act: ""
        suffix: ""
        default: "'0"
      }
      {
        package: ""
        struct: logic
        domain: chip
        signame: cio_i3c0_scl_d2p
        width: 1
        type: uni
        end_idx: -1
        act: ""
        suffix: ""
        default: "'0"
      }
      {
        package: ""
        struct: logic
        domain: chip
        signame: cio_i3c0_scl_en_d2p
        width: 1
        type: uni
        end_idx: -1
        act: ""
        suffix: ""
        default: "'0"
      }
      {
        package: ""
        struct: logic
        domain: chip
        signame: cio_i3c0_scl_p2d
        width: 1
        type: uni
        end_idx: -1
        act: ""
        suffix: ""
        default: "'0"
      }
      {
        package: ""
        struct: logic
        domain: chip
        signame: cio_i3c0_sda_d2p
        width: 1
        type: uni
        end_idx: -1
        act: ""
        suffix: ""
        default: "'0"
      }
      {
        package: ""
        struct: logic
        domain: chip
        signame: cio_i3c0_sda_en_d2p
        width: 1
        type: uni
        end_idx: -1
        act: ""
        suffix: ""
        default: "'0"
      }
      {
        package: ""
        struct: logic
        domain: chip
        signame: cio_i3c0_sda_p2d
        width: 1
        type: uni
        end_idx: -1
        act: ""
        suffix: ""
        default: "'0"
      }
      {
        package: ""
        struct: logic
        domain: chip
        signame: cio_i3c0_ctrl_sda_pu_d2p
        width: 1
        type: uni
        end_idx: -1
        act: ""
        suffix: ""
        default: "'0"
      }
      {
        package: ""
        struct: logic
        domain: chip
        signame: cio_i3c0_ctrl_sda_pu_en_d2p
        width: 1
        type: uni
        end_idx: -1
        act: ""
        suffix: ""
        default: "'0"
      }
      {
        package: ""
        struct: logic
        domain: chip
        signame: cio_i3c1_scl_d2p
        width: 1
        type: uni
        end_idx: -1
        act: ""
        suffix: ""
        default: "'0"
      }
      {
        package: ""
        struct: logic
        domain: chip
        signame: cio_i3c1_scl_en_d2p
        width: 1
        type: uni
        end_idx: -1
        act: ""
        suffix: ""
        default: "'0"
      }
      {
        package: ""
        struct: logic
        domain: chip
        signame: cio_i3c1_scl_p2d
        width: 1
        type: uni
        end_idx: -1
        act: ""
        suffix: ""
        default: "'0"
      }
      {
        package: ""
        struct: logic
        domain: chip
        signame: cio_i3c1_sda_d2p
        width: 1
        type: uni
        end_idx: -1
        act: ""
        suffix: ""
        default: "'0"
      }
      {
        package: ""
        struct: logic
        domain: chip
        signame: cio_i3c1_sda_en_d2p
        width: 1
        type: uni
        end_idx: -1
        act: ""
        suffix: ""
        default: "'0"
      }
      {
        package: ""
        struct: logic
        domain: chip
        signame: cio_i3c1_sda_p2d
        width: 1
        type: uni
        end_idx: -1
        act: ""
        suffix: ""
        default: "'0"
      }
      {
        package: ""
        struct: logic
        domain: chip
        signame: cio_i3c1_rstdet_scl_p2d
        width: 1
        type: uni
        end_idx: -1
        act: ""
        suffix: ""
        default: "'0"
      }
      {
        package: ""
        struct: logic
        domain: chip
        signame: cio_i3c1_rstdet_sda_p2d
        width: 1
        type: uni
        end_idx: -1
        act: ""
        suffix: ""
        default: "'0"
      }
      {
        package: ""
        struct: logic
        domain: chip
        signame: cio_i3c1_ctrl_sda_pu_d2p
        width: 1
        type: uni
        end_idx: -1
        act: ""
        suffix: ""
        default: "'0"
      }
      {
        package: ""
        struct: logic
        domain: chip
        signame: cio_i3c1_ctrl_sda_pu_en_d2p
        width: 1
        type: uni
        end_idx: -1
        act: ""
        suffix: ""
        default: "'0"
      }
      {
        package: ""
        struct: logic
        domain: chip
        signame: cio_spi_host0_sd_d2p
        width: 4
        type: uni
        end_idx: -1
        act: ""
        suffix: ""
        default: "'0"
      }
      {
        package: ""
        struct: logic
        domain: chip
        signame: cio_spi_host0_sd_en_d2p
        width: 4
        type: uni
        end_idx: -1
        act: ""
        suffix: ""
        default: "'0"
      }
      {
        package: ""
        struct: logic
        domain: chip
        signame: cio_spi_host0_sd_p2d
        width: 4
        type: uni
        end_idx: -1
        act: ""
        suffix: ""
        default: "'0"
      }
      {
        package: ""
        struct: logic
        domain: chip
        signame: cio_spi_host0_sck_d2p
        width: 1
        type: uni
        end_idx: -1
        act: ""
        suffix: ""
        default: "'0"
      }
      {
        package: ""
        struct: logic
        domain: chip
        signame: cio_spi_host0_sck_en_d2p
        width: 1
        type: uni
        end_idx: -1
        act: ""
        suffix: ""
        default: "'0"
      }
      {
        package: ""
        struct: logic
        domain: chip
        signame: cio_spi_host0_csb_d2p
        width: 3
        type: uni
        end_idx: -1
        act: ""
        suffix: ""
        default: "'0"
      }
      {
        package: ""
        struct: logic
        domain: chip
        signame: cio_spi_host0_csb_en_d2p
        width: 3
        type: uni
        end_idx: -1
        act: ""
        suffix: ""
        default: "'0"
      }
      {
        package: ""
        struct: logic
        domain: chip
        signame: cio_spi_host1_sd_d2p
        width: 4
        type: uni
        end_idx: -1
        act: ""
        suffix: ""
        default: "'0"
      }
      {
        package: ""
        struct: logic
        domain: chip
        signame: cio_spi_host1_sd_en_d2p
        width: 4
        type: uni
        end_idx: -1
        act: ""
        suffix: ""
        default: "'0"
      }
      {
        package: ""
        struct: logic
        domain: chip
        signame: cio_spi_host1_sd_p2d
        width: 4
        type: uni
        end_idx: -1
        act: ""
        suffix: ""
        default: "'0"
      }
      {
        package: ""
        struct: logic
        domain: chip
        signame: cio_spi_host1_sck_d2p
        width: 1
        type: uni
        end_idx: -1
        act: ""
        suffix: ""
        default: "'0"
      }
      {
        package: ""
        struct: logic
        domain: chip
        signame: cio_spi_host1_sck_en_d2p
        width: 1
        type: uni
        end_idx: -1
        act: ""
        suffix: ""
        default: "'0"
      }
      {
        package: ""
        struct: logic
        domain: chip
        signame: cio_spi_host1_csb_d2p
        width: 3
        type: uni
        end_idx: -1
        act: ""
        suffix: ""
        default: "'0"
      }
      {
        package: ""
        struct: logic
        domain: chip
        signame: cio_spi_host1_csb_en_d2p
        width: 3
        type: uni
        end_idx: -1
        act: ""
        suffix: ""
        default: "'0"
      }
      {
        package: ""
        struct: logic
        domain: chip
        signame: cio_usbdev_usb_dp_d2p
        width: 1
        type: uni
        end_idx: -1
        act: ""
        suffix: ""
        default: "'0"
      }
      {
        package: ""
        struct: logic
        domain: chip
        signame: cio_usbdev_usb_dp_en_d2p
        width: 1
        type: uni
        end_idx: -1
        act: ""
        suffix: ""
        default: "'0"
      }
      {
        package: ""
        struct: logic
        domain: chip
        signame: cio_usbdev_usb_dp_p2d
        width: 1
        type: uni
        end_idx: -1
        act: ""
        suffix: ""
        default: "'0"
      }
      {
        package: ""
        struct: logic
        domain: chip
        signame: cio_usbdev_usb_dn_d2p
        width: 1
        type: uni
        end_idx: -1
        act: ""
        suffix: ""
        default: "'0"
      }
      {
        package: ""
        struct: logic
        domain: chip
        signame: cio_usbdev_usb_dn_en_d2p
        width: 1
        type: uni
        end_idx: -1
        act: ""
        suffix: ""
        default: "'0"
      }
      {
        package: ""
        struct: logic
        domain: chip
        signame: cio_usbdev_usb_dn_p2d
        width: 1
        type: uni
        end_idx: -1
        act: ""
        suffix: ""
        default: "'0"
      }
      {
        package: ""
        struct: logic
        domain: chip
        signame: cio_usbdev_sense_p2d
        width: 1
        type: uni
        end_idx: -1
        act: ""
        suffix: ""
        default: "'0"
      }
      {
        package: ""
        struct: logic
        domain: chip
        signame: ast_clk_src_sys
        width: 1
        type: uni
        end_idx: -1
        default: 1'b0
      }
      {
        package: ""
        struct: logic
        domain: chip
        signame: ast_clk_src_io
        width: 1
        type: uni
        end_idx: -1
        default: 1'b0
      }
      {
        package: ""
        struct: logic
        domain: chip
        signame: ast_clk_src_usb
        width: 1
        type: uni
        end_idx: -1
        default: 1'b0
      }
    ]
  }
  alert_module:
  [
    uart0
    uart1
    uart2
    uart3
    gpio0
    gpio1
    spi_device
    i2c0
    i2c1
    i2c2
    i3c0
    i3c1
    rv_timer
    otp_ctrl
    lc_ctrl
    spi_host0
    spi_host1
    usbdev
    pwrmgr
    rstmgr
    clkmgr
    sysrst_ctrl
    adc_ctrl
    pinmux
    aon_timer
    sensor_ctrl
    sram_ctrl_ret
    rram_ctrl
    rv_dm
    rv_plic
    aes
    hmac
    kmac
    otbn
    keymgr_dpe
    csrng
    entropy_src
    edn0
    edn1
    sram_ctrl_main
    sram_ctrl_sec
    rom_ctrl
    rv_core_ibex
    cheriot_mem_sys
    sram_ctrl_meta
  ]
  alert_connections:
  {
    module_uart0:
    {
      tx_expr: alert_tx[0]
      rx_expr: alert_rx[0]
      async_expr: alert_handler_reg_pkg::AsyncOn[0]
      comments:
      [
        alert_handler[0]: fatal_fault
      ]
    }
    module_uart1:
    {
      tx_expr: alert_tx[1]
      rx_expr: alert_rx[1]
      async_expr: alert_handler_reg_pkg::AsyncOn[1]
      comments:
      [
        alert_handler[1]: fatal_fault
      ]
    }
    module_uart2:
    {
      tx_expr: alert_tx[2]
      rx_expr: alert_rx[2]
      async_expr: alert_handler_reg_pkg::AsyncOn[2]
      comments:
      [
        alert_handler[2]: fatal_fault
      ]
    }
    module_uart3:
    {
      tx_expr: alert_tx[3]
      rx_expr: alert_rx[3]
      async_expr: alert_handler_reg_pkg::AsyncOn[3]
      comments:
      [
        alert_handler[3]: fatal_fault
      ]
    }
    module_gpio0:
    {
      tx_expr: alert_tx[4]
      rx_expr: alert_rx[4]
      async_expr: alert_handler_reg_pkg::AsyncOn[4]
      comments:
      [
        alert_handler[4]: fatal_fault
      ]
    }
    module_gpio1:
    {
      tx_expr: alert_tx[5]
      rx_expr: alert_rx[5]
      async_expr: alert_handler_reg_pkg::AsyncOn[5]
      comments:
      [
        alert_handler[5]: fatal_fault
      ]
    }
    module_spi_device:
    {
      tx_expr: alert_tx[6]
      rx_expr: alert_rx[6]
      async_expr: alert_handler_reg_pkg::AsyncOn[6]
      comments:
      [
        alert_handler[6]: fatal_fault
      ]
    }
    module_i2c0:
    {
      tx_expr: alert_tx[7]
      rx_expr: alert_rx[7]
      async_expr: alert_handler_reg_pkg::AsyncOn[7]
      comments:
      [
        alert_handler[7]: fatal_fault
      ]
    }
    module_i2c1:
    {
      tx_expr: alert_tx[8]
      rx_expr: alert_rx[8]
      async_expr: alert_handler_reg_pkg::AsyncOn[8]
      comments:
      [
        alert_handler[8]: fatal_fault
      ]
    }
    module_i2c2:
    {
      tx_expr: alert_tx[9]
      rx_expr: alert_rx[9]
      async_expr: alert_handler_reg_pkg::AsyncOn[9]
      comments:
      [
        alert_handler[9]: fatal_fault
      ]
    }
    module_i3c0:
    {
      tx_expr: alert_tx[10]
      rx_expr: alert_rx[10]
      async_expr: alert_handler_reg_pkg::AsyncOn[10]
      comments:
      [
        alert_handler[10]: fatal_fault
      ]
    }
    module_i3c1:
    {
      tx_expr: alert_tx[11]
      rx_expr: alert_rx[11]
      async_expr: alert_handler_reg_pkg::AsyncOn[11]
      comments:
      [
        alert_handler[11]: fatal_fault
      ]
    }
    module_rv_timer:
    {
      tx_expr: alert_tx[12]
      rx_expr: alert_rx[12]
      async_expr: alert_handler_reg_pkg::AsyncOn[12]
      comments:
      [
        alert_handler[12]: fatal_fault
      ]
    }
    module_otp_ctrl:
    {
      tx_expr: alert_tx[17:13]
      rx_expr: alert_rx[17:13]
      async_expr: alert_handler_reg_pkg::AsyncOn[17:13]
      comments:
      [
        alert_handler[13]: fatal_macro_error
        alert_handler[14]: fatal_check_error
        alert_handler[15]: fatal_bus_integ_error
        alert_handler[16]: fatal_prim_otp_alert
        alert_handler[17]: recov_prim_otp_alert
      ]
    }
    module_lc_ctrl:
    {
      tx_expr: alert_tx[20:18]
      rx_expr: alert_rx[20:18]
      async_expr: alert_handler_reg_pkg::AsyncOn[20:18]
      comments:
      [
        alert_handler[18]: fatal_prog_error
        alert_handler[19]: fatal_state_error
        alert_handler[20]: fatal_bus_integ_error
      ]
    }
    module_spi_host0:
    {
      tx_expr: alert_tx[21]
      rx_expr: alert_rx[21]
      async_expr: alert_handler_reg_pkg::AsyncOn[21]
      comments:
      [
        alert_handler[21]: fatal_fault
      ]
    }
    module_spi_host1:
    {
      tx_expr: alert_tx[22]
      rx_expr: alert_rx[22]
      async_expr: alert_handler_reg_pkg::AsyncOn[22]
      comments:
      [
        alert_handler[22]: fatal_fault
      ]
    }
    module_usbdev:
    {
      tx_expr: alert_tx[23]
      rx_expr: alert_rx[23]
      async_expr: alert_handler_reg_pkg::AsyncOn[23]
      comments:
      [
        alert_handler[23]: fatal_fault
      ]
    }
    module_pwrmgr:
    {
      tx_expr: alert_tx_o[0]
      rx_expr: alert_rx_i[0]
      async_expr: alert_handler_reg_pkg::AsyncOn[24]
      comments:
      [
        alert_handler[24]: fatal_fault
      ]
    }
    module_rstmgr:
    {
      tx_expr: alert_tx_o[2:1]
      rx_expr: alert_rx_i[2:1]
      async_expr: alert_handler_reg_pkg::AsyncOn[26:25]
      comments:
      [
        alert_handler[25]: fatal_fault
        alert_handler[26]: fatal_cnsty_fault
      ]
    }
    module_clkmgr:
    {
      tx_expr: alert_tx_o[4:3]
      rx_expr: alert_rx_i[4:3]
      async_expr: alert_handler_reg_pkg::AsyncOn[28:27]
      comments:
      [
        alert_handler[27]: recov_fault
        alert_handler[28]: fatal_fault
      ]
    }
    module_sysrst_ctrl:
    {
      tx_expr: alert_tx_o[5]
      rx_expr: alert_rx_i[5]
      async_expr: alert_handler_reg_pkg::AsyncOn[29]
      comments:
      [
        alert_handler[29]: fatal_fault
      ]
    }
    module_adc_ctrl:
    {
      tx_expr: alert_tx_o[6]
      rx_expr: alert_rx_i[6]
      async_expr: alert_handler_reg_pkg::AsyncOn[30]
      comments:
      [
        alert_handler[30]: fatal_fault
      ]
    }
    module_pinmux:
    {
      tx_expr: alert_tx_o[7]
      rx_expr: alert_rx_i[7]
      async_expr: alert_handler_reg_pkg::AsyncOn[31]
      comments:
      [
        alert_handler[31]: fatal_fault
      ]
    }
    module_aon_timer:
    {
      tx_expr: alert_tx_o[8]
      rx_expr: alert_rx_i[8]
      async_expr: alert_handler_reg_pkg::AsyncOn[32]
      comments:
      [
        alert_handler[32]: fatal_fault
      ]
    }
    module_sensor_ctrl:
    {
      tx_expr: alert_tx_o[10:9]
      rx_expr: alert_rx_i[10:9]
      async_expr: alert_handler_reg_pkg::AsyncOn[34:33]
      comments:
      [
        alert_handler[33]: recov_alert
        alert_handler[34]: fatal_alert
      ]
    }
    module_sram_ctrl_ret:
    {
      tx_expr: alert_tx_o[11]
      rx_expr: alert_rx_i[11]
      async_expr: alert_handler_reg_pkg::AsyncOn[35]
      comments:
      [
        alert_handler[35]: fatal_error
      ]
    }
    module_rram_ctrl:
    {
      tx_expr: alert_tx[40:36]
      rx_expr: alert_rx[40:36]
      async_expr: alert_handler_reg_pkg::AsyncOn[40:36]
      comments:
      [
        alert_handler[36]: recov_err
        alert_handler[37]: fatal_std_err
        alert_handler[38]: fatal_err
        alert_handler[39]: fatal_macro_err
        alert_handler[40]: recov_macro_err
      ]
    }
    module_rv_dm:
    {
      tx_expr: alert_tx[41]
      rx_expr: alert_rx[41]
      async_expr: alert_handler_reg_pkg::AsyncOn[41]
      comments:
      [
        alert_handler[41]: fatal_fault
      ]
    }
    module_rv_plic:
    {
      tx_expr: alert_tx[42]
      rx_expr: alert_rx[42]
      async_expr: alert_handler_reg_pkg::AsyncOn[42]
      comments:
      [
        alert_handler[42]: fatal_fault
      ]
    }
    module_aes:
    {
      tx_expr: alert_tx[44:43]
      rx_expr: alert_rx[44:43]
      async_expr: alert_handler_reg_pkg::AsyncOn[44:43]
      comments:
      [
        alert_handler[43]: recov_ctrl_update_err
        alert_handler[44]: fatal_fault
      ]
    }
    module_hmac:
    {
      tx_expr: alert_tx[45]
      rx_expr: alert_rx[45]
      async_expr: alert_handler_reg_pkg::AsyncOn[45]
      comments:
      [
        alert_handler[45]: fatal_fault
      ]
    }
    module_kmac:
    {
      tx_expr: alert_tx[47:46]
      rx_expr: alert_rx[47:46]
      async_expr: alert_handler_reg_pkg::AsyncOn[47:46]
      comments:
      [
        alert_handler[46]: recov_operation_err
        alert_handler[47]: fatal_fault_err
      ]
    }
    module_otbn:
    {
      tx_expr: alert_tx[49:48]
      rx_expr: alert_rx[49:48]
      async_expr: alert_handler_reg_pkg::AsyncOn[49:48]
      comments:
      [
        alert_handler[48]: fatal
        alert_handler[49]: recov
      ]
    }
    module_keymgr_dpe:
    {
      tx_expr: alert_tx[51:50]
      rx_expr: alert_rx[51:50]
      async_expr: alert_handler_reg_pkg::AsyncOn[51:50]
      comments:
      [
        alert_handler[50]: recov_operation_err
        alert_handler[51]: fatal_fault_err
      ]
    }
    module_csrng:
    {
      tx_expr: alert_tx[53:52]
      rx_expr: alert_rx[53:52]
      async_expr: alert_handler_reg_pkg::AsyncOn[53:52]
      comments:
      [
        alert_handler[52]: recov_alert
        alert_handler[53]: fatal_alert
      ]
    }
    module_entropy_src:
    {
      tx_expr: alert_tx[55:54]
      rx_expr: alert_rx[55:54]
      async_expr: alert_handler_reg_pkg::AsyncOn[55:54]
      comments:
      [
        alert_handler[54]: recov_alert
        alert_handler[55]: fatal_alert
      ]
    }
    module_edn0:
    {
      tx_expr: alert_tx[57:56]
      rx_expr: alert_rx[57:56]
      async_expr: alert_handler_reg_pkg::AsyncOn[57:56]
      comments:
      [
        alert_handler[56]: recov_alert
        alert_handler[57]: fatal_alert
      ]
    }
    module_edn1:
    {
      tx_expr: alert_tx[59:58]
      rx_expr: alert_rx[59:58]
      async_expr: alert_handler_reg_pkg::AsyncOn[59:58]
      comments:
      [
        alert_handler[58]: recov_alert
        alert_handler[59]: fatal_alert
      ]
    }
    module_sram_ctrl_main:
    {
      tx_expr: alert_tx[60]
      rx_expr: alert_rx[60]
      async_expr: alert_handler_reg_pkg::AsyncOn[60]
      comments:
      [
        alert_handler[60]: fatal_error
      ]
    }
    module_sram_ctrl_sec:
    {
      tx_expr: alert_tx[61]
      rx_expr: alert_rx[61]
      async_expr: alert_handler_reg_pkg::AsyncOn[61]
      comments:
      [
        alert_handler[61]: fatal_error
      ]
    }
    module_rom_ctrl:
    {
      tx_expr: alert_tx[62]
      rx_expr: alert_rx[62]
      async_expr: alert_handler_reg_pkg::AsyncOn[62]
      comments:
      [
        alert_handler[62]: fatal
      ]
    }
    module_rv_core_ibex:
    {
      tx_expr: alert_tx[66:63]
      rx_expr: alert_rx[66:63]
      async_expr: alert_handler_reg_pkg::AsyncOn[66:63]
      comments:
      [
        alert_handler[63]: fatal_sw_err
        alert_handler[64]: recov_sw_err
        alert_handler[65]: fatal_hw_err
        alert_handler[66]: recov_hw_err
      ]
    }
    module_cheriot_mem_sys:
    {
      tx_expr: alert_tx[67]
      rx_expr: alert_rx[67]
      async_expr: alert_handler_reg_pkg::AsyncOn[67]
      comments:
      [
        alert_handler[67]: fatal_fault
      ]
    }
    module_sram_ctrl_meta:
    {
      tx_expr: alert_tx[68]
      rx_expr: alert_rx[68]
      async_expr: alert_handler_reg_pkg::AsyncOn[68]
      comments:
      [
        alert_handler[68]: fatal_error
      ]
    }
  }
  alert_handler_info:
  {
    alert_handler:
    {
      domain: Main
      count_tot: 69
      count_pd:
      {
        Aon: 12
        Main: 57
      }
      connect_pd:
      {
        24:
        {
          src_pd: Aon
          idx: 0
        }
        25:
        {
          src_pd: Aon
          idx: 1
        }
        26:
        {
          src_pd: Aon
          idx: 2
        }
        27:
        {
          src_pd: Aon
          idx: 3
        }
        28:
        {
          src_pd: Aon
          idx: 4
        }
        29:
        {
          src_pd: Aon
          idx: 5
        }
        30:
        {
          src_pd: Aon
          idx: 6
        }
        31:
        {
          src_pd: Aon
          idx: 7
        }
        32:
        {
          src_pd: Aon
          idx: 8
        }
        33:
        {
          src_pd: Aon
          idx: 9
        }
        34:
        {
          src_pd: Aon
          idx: 10
        }
        35:
        {
          src_pd: Aon
          idx: 11
        }
      }
    }
  }
  interrupt_module:
  [
    uart0
    uart1
    uart2
    uart3
    gpio0
    gpio1
    spi_device
    i2c0
    i2c1
    i2c2
    i3c0
    i3c1
    rv_timer
    otp_ctrl
    alert_handler
    spi_host0
    spi_host1
    usbdev
    pwrmgr
    sysrst_ctrl
    adc_ctrl
    aon_timer
    sensor_ctrl
    rram_ctrl
    hmac
    kmac
    otbn
    keymgr_dpe
    csrng
    entropy_src
    edn0
    edn1
    cheriot_mem_sys
  ]
  outgoing_alert_module: {}
  outgoing_interrupt_module: {}
  alert_lpgs:
  [
    {
      name: peri_lc_io_div4_Main
      clock_group:
      {
        name: peri
        src: top
        sw_cg: yes
        unique: no
        clocks:
        {
          clk_io_div4_peri: io_div4
          clk_io_peri: io
          clk_aon_peri: aon
          clk_usb_peri: usb
        }
      }
      clock_connection: clkmgr_clocks_i.clk_io_div4_peri
      unmanaged_clock: false
      unmanaged_reset: false
      reset_connection:
      {
        name: lc_io_div4
        domain: Main
      }
    }
    {
      name: peri_spi_device_Main
      clock_group:
      {
        name: peri
        src: top
        sw_cg: yes
        unique: no
        clocks:
        {
          clk_io_div4_peri: io_div4
          clk_io_peri: io
          clk_aon_peri: aon
          clk_usb_peri: usb
        }
      }
      clock_connection: clkmgr_clocks_i.clk_io_div4_peri
      unmanaged_clock: false
      unmanaged_reset: false
      reset_connection:
      {
        name: spi_device
        domain: Main
      }
    }
    {
      name: peri_i2c0_Main
      clock_group:
      {
        name: peri
        src: top
        sw_cg: yes
        unique: no
        clocks:
        {
          clk_io_div4_peri: io_div4
          clk_io_peri: io
          clk_aon_peri: aon
          clk_usb_peri: usb
        }
      }
      clock_connection: clkmgr_clocks_i.clk_io_div4_peri
      unmanaged_clock: false
      unmanaged_reset: false
      reset_connection:
      {
        name: i2c0
        domain: Main
      }
    }
    {
      name: peri_i2c1_Main
      clock_group:
      {
        name: peri
        src: top
        sw_cg: yes
        unique: no
        clocks:
        {
          clk_io_div4_peri: io_div4
          clk_io_peri: io
          clk_aon_peri: aon
          clk_usb_peri: usb
        }
      }
      clock_connection: clkmgr_clocks_i.clk_io_div4_peri
      unmanaged_clock: false
      unmanaged_reset: false
      reset_connection:
      {
        name: i2c1
        domain: Main
      }
    }
    {
      name: peri_i2c2_Main
      clock_group:
      {
        name: peri
        src: top
        sw_cg: yes
        unique: no
        clocks:
        {
          clk_io_div4_peri: io_div4
          clk_io_peri: io
          clk_aon_peri: aon
          clk_usb_peri: usb
        }
      }
      clock_connection: clkmgr_clocks_i.clk_io_div4_peri
      unmanaged_clock: false
      unmanaged_reset: false
      reset_connection:
      {
        name: i2c2
        domain: Main
      }
    }
    {
      name: peri_i3c0_Main
      clock_group:
      {
        name: peri
        src: top
        sw_cg: yes
        unique: no
        clocks:
        {
          clk_io_div4_peri: io_div4
          clk_io_peri: io
          clk_aon_peri: aon
          clk_usb_peri: usb
        }
      }
      clock_connection: clkmgr_clocks_i.clk_io_peri
      unmanaged_clock: false
      unmanaged_reset: false
      reset_connection:
      {
        name: i3c0
        domain: Main
      }
    }
    {
      name: peri_lc_aon_Aon
      clock_group:
      {
        name: peri
        src: top
        sw_cg: yes
        unique: no
        clocks:
        {
          clk_io_div4_peri: io_div4
          clk_io_peri: io
          clk_aon_peri: aon
          clk_usb_peri: usb
        }
      }
      clock_connection: clkmgr_clocks.clk_aon_peri
      unmanaged_clock: false
      unmanaged_reset: false
      reset_connection:
      {
        name: lc_aon
        domain: Aon
      }
    }
    {
      name: peri_i3c1_Main
      clock_group:
      {
        name: peri
        src: top
        sw_cg: yes
        unique: no
        clocks:
        {
          clk_io_div4_peri: io_div4
          clk_io_peri: io
          clk_aon_peri: aon
          clk_usb_peri: usb
        }
      }
      clock_connection: clkmgr_clocks_i.clk_io_peri
      unmanaged_clock: false
      unmanaged_reset: false
      reset_connection:
      {
        name: i3c1
        domain: Main
      }
    }
    {
      name: peri_lc_aon_Main
      clock_group:
      {
        name: peri
        src: top
        sw_cg: yes
        unique: no
        clocks:
        {
          clk_io_div4_peri: io_div4
          clk_io_peri: io
          clk_aon_peri: aon
          clk_usb_peri: usb
        }
      }
      clock_connection: clkmgr_clocks_i.clk_aon_peri
      unmanaged_clock: false
      unmanaged_reset: false
      reset_connection:
      {
        name: lc_aon
        domain: Main
      }
    }
    {
      name: timers_lc_io_div4_Main
      clock_group:
      {
        name: timers
        src: top
        sw_cg: no
        unique: no
        clocks:
        {
          clk_io_div4_timers: io_div4
          clk_aon_timers: aon
        }
      }
      clock_connection: clkmgr_clocks_i.clk_io_div4_timers
      unmanaged_clock: false
      unmanaged_reset: false
      reset_connection:
      {
        name: lc_io_div4
        domain: Main
      }
    }
    {
      name: secure_lc_io_div4_Main
      clock_group:
      {
        name: secure
        src: top
        sw_cg: no
        unique: no
        clocks:
        {
          clk_io_div4_secure: io_div4
          clk_main_secure: main
          clk_aon_secure: aon
        }
      }
      clock_connection: clkmgr_clocks_i.clk_io_div4_secure
      unmanaged_clock: false
      unmanaged_reset: false
      reset_connection:
      {
        name: lc_io_div4
        domain: Main
      }
    }
    {
      name: peri_spi_host0_Main
      clock_group:
      {
        name: peri
        src: top
        sw_cg: yes
        unique: no
        clocks:
        {
          clk_io_div4_peri: io_div4
          clk_io_peri: io
          clk_aon_peri: aon
          clk_usb_peri: usb
        }
      }
      clock_connection: clkmgr_clocks_i.clk_io_peri
      unmanaged_clock: false
      unmanaged_reset: false
      reset_connection:
      {
        name: spi_host0
        domain: Main
      }
    }
    {
      name: spi_host1_spi_host1_Main
      clock_group:
      {
        name: spi_host1
        src: top
        sw_cg: yes
        unique: no
        clocks:
        {
          clk_io_spi_host1: io
        }
      }
      clock_connection: clkmgr_clocks_i.clk_io_spi_host1
      unmanaged_clock: false
      unmanaged_reset: false
      reset_connection:
      {
        name: spi_host1
        domain: Main
      }
    }
    {
      name: peri_usb_Main
      clock_group:
      {
        name: peri
        src: top
        sw_cg: yes
        unique: no
        clocks:
        {
          clk_io_div4_peri: io_div4
          clk_io_peri: io
          clk_aon_peri: aon
          clk_usb_peri: usb
        }
      }
      clock_connection: clkmgr_clocks_i.clk_usb_peri
      unmanaged_clock: false
      unmanaged_reset: false
      reset_connection:
      {
        name: usb
        domain: Main
      }
    }
    {
      name: powerup_por_io_div4_Aon
      clock_group:
      {
        name: powerup
        src: top
        sw_cg: no
        unique: no
        clocks:
        {
          clk_io_div4_powerup: io_div4
          clk_aon_powerup: aon
          clk_main_powerup: main
          clk_io_powerup: io
          clk_usb_powerup: usb
        }
      }
      clock_connection: clkmgr_clocks.clk_io_div4_powerup
      unmanaged_clock: false
      unmanaged_reset: false
      reset_connection:
      {
        name: por_io_div4
        domain: Aon
      }
    }
    {
      name: powerup_lc_io_div4_Aon
      clock_group:
      {
        name: powerup
        src: top
        sw_cg: no
        unique: no
        clocks:
        {
          clk_io_div4_powerup: io_div4
          clk_aon_powerup: aon
          clk_main_powerup: main
          clk_io_powerup: io
          clk_usb_powerup: usb
        }
      }
      clock_connection: clkmgr_clocks.clk_io_div4_powerup
      unmanaged_clock: false
      unmanaged_reset: false
      reset_connection:
      {
        name: lc_io_div4
        domain: Aon
      }
    }
    {
      name: secure_lc_io_div4_Aon
      clock_group:
      {
        name: secure
        src: top
        sw_cg: no
        unique: no
        clocks:
        {
          clk_io_div4_secure: io_div4
          clk_main_secure: main
          clk_aon_secure: aon
        }
      }
      clock_connection: clkmgr_clocks.clk_io_div4_secure
      unmanaged_clock: false
      unmanaged_reset: false
      reset_connection:
      {
        name: lc_io_div4
        domain: Aon
      }
    }
    {
      name: peri_lc_io_div4_Aon
      clock_group:
      {
        name: peri
        src: top
        sw_cg: yes
        unique: no
        clocks:
        {
          clk_io_div4_peri: io_div4
          clk_io_peri: io
          clk_aon_peri: aon
          clk_usb_peri: usb
        }
      }
      clock_connection: clkmgr_clocks.clk_io_div4_peri
      unmanaged_clock: false
      unmanaged_reset: false
      reset_connection:
      {
        name: lc_io_div4
        domain: Aon
      }
    }
    {
      name: timers_lc_io_div4_Aon
      clock_group:
      {
        name: timers
        src: top
        sw_cg: no
        unique: no
        clocks:
        {
          clk_io_div4_timers: io_div4
          clk_aon_timers: aon
        }
      }
      clock_connection: clkmgr_clocks.clk_io_div4_timers
      unmanaged_clock: false
      unmanaged_reset: false
      reset_connection:
      {
        name: lc_io_div4
        domain: Aon
      }
    }
    {
      name: infra_lc_io_div4_Main
      clock_group:
      {
        name: infra
        src: top
        sw_cg: no
        unique: no
        clocks:
        {
          clk_io_div4_infra: io_div4
          clk_main_infra: main
          clk_usb_infra: usb
          clk_io_infra: io
        }
      }
      clock_connection: clkmgr_clocks_i.clk_io_div4_infra
      unmanaged_clock: false
      unmanaged_reset: false
      reset_connection:
      {
        name: lc_io_div4
        domain: Main
      }
    }
    {
      name: infra_lc_io_div4_Aon
      clock_group:
      {
        name: infra
        src: top
        sw_cg: no
        unique: no
        clocks:
        {
          clk_io_div4_infra: io_div4
          clk_main_infra: main
          clk_usb_infra: usb
          clk_io_infra: io
        }
      }
      clock_connection: clkmgr_clocks.clk_io_div4_infra
      unmanaged_clock: false
      unmanaged_reset: false
      reset_connection:
      {
        name: lc_io_div4
        domain: Aon
      }
    }
    {
      name: infra_lc_Main
      clock_group:
      {
        name: infra
        src: top
        sw_cg: no
        unique: no
        clocks:
        {
          clk_io_div4_infra: io_div4
          clk_main_infra: main
          clk_usb_infra: usb
          clk_io_infra: io
        }
      }
      clock_connection: clkmgr_clocks_i.clk_main_infra
      unmanaged_clock: false
      unmanaged_reset: false
      reset_connection:
      {
        name: lc
        domain: Main
      }
    }
    {
      name: infra_sys_Main
      clock_group:
      {
        name: infra
        src: top
        sw_cg: no
        unique: no
        clocks:
        {
          clk_io_div4_infra: io_div4
          clk_main_infra: main
          clk_usb_infra: usb
          clk_io_infra: io
        }
      }
      clock_connection: clkmgr_clocks_i.clk_main_infra
      unmanaged_clock: false
      unmanaged_reset: false
      reset_connection:
      {
        name: sys
        domain: Main
      }
    }
    {
      name: secure_lc_Main
      clock_group:
      {
        name: secure
        src: top
        sw_cg: no
        unique: no
        clocks:
        {
          clk_io_div4_secure: io_div4
          clk_main_secure: main
          clk_aon_secure: aon
        }
      }
      clock_connection: clkmgr_clocks_i.clk_main_secure
      unmanaged_clock: false
      unmanaged_reset: false
      reset_connection:
      {
        name: lc
        domain: Main
      }
    }
    {
      name: aes_trans_lc_Main
      clock_group:
      {
        name: trans
        src: top
        sw_cg: hint
        unique: yes
        clocks:
        {
          clk_main_aes: main
          clk_main_hmac: main
          clk_main_kmac: main
          clk_main_otbn: main
        }
      }
      clock_connection: clkmgr_clocks_i.clk_main_aes
      unmanaged_clock: false
      unmanaged_reset: false
      reset_connection:
      {
        name: lc
        domain: Main
      }
    }
    {
      name: hmac_trans_lc_Main
      clock_group:
      {
        name: trans
        src: top
        sw_cg: hint
        unique: yes
        clocks:
        {
          clk_main_aes: main
          clk_main_hmac: main
          clk_main_kmac: main
          clk_main_otbn: main
        }
      }
      clock_connection: clkmgr_clocks_i.clk_main_hmac
      unmanaged_clock: false
      unmanaged_reset: false
      reset_connection:
      {
        name: lc
        domain: Main
      }
    }
    {
      name: kmac_trans_lc_Main
      clock_group:
      {
        name: trans
        src: top
        sw_cg: hint
        unique: yes
        clocks:
        {
          clk_main_aes: main
          clk_main_hmac: main
          clk_main_kmac: main
          clk_main_otbn: main
        }
      }
      clock_connection: clkmgr_clocks_i.clk_main_kmac
      unmanaged_clock: false
      unmanaged_reset: false
      reset_connection:
      {
        name: lc
        domain: Main
      }
    }
    {
      name: otbn_trans_lc_Main
      clock_group:
      {
        name: trans
        src: top
        sw_cg: hint
        unique: yes
        clocks:
        {
          clk_main_aes: main
          clk_main_hmac: main
          clk_main_kmac: main
          clk_main_otbn: main
        }
      }
      clock_connection: clkmgr_clocks_i.clk_main_otbn
      unmanaged_clock: false
      unmanaged_reset: false
      reset_connection:
      {
        name: lc
        domain: Main
      }
    }
  ]
  outgoing_alert_lpgs: {}
  inter_signal:
  {
    signals:
    [
      {
        name: lsio_trigger
        desc:
          '''
          Self-clearing status trigger for the DMA.
          Set when RX or TX FIFOs are past their configured watermarks matching watermark interrupt behaviour.
          '''
        struct: logic
        type: uni
        act: req
        width: 1
        inst_name: uart0
        index: -1
      }
      {
        name: racl_policies
        desc:
          '''
          Incoming RACL policy vector from a racl_ctrl instance.
          The policy selection vector (parameter) selects the policy for each register.
          '''
        struct: racl_policy_vec
        package: top_racl_pkg
        type: uni
        act: rcv
        width: 1
        inst_name: uart0
        index: -1
      }
      {
        name: racl_error
        desc: RACL error log information of this module.
        struct: racl_error_log
        package: top_racl_pkg
        type: uni
        act: req
        width: 1
        inst_name: uart0
        index: -1
      }
      {
        name: tl
        struct: tl
        package: tlul_pkg
        type: req_rsp
        act: rsp
        width: 1
        inst_name: uart0
        default: ""
        end_idx: -1
        top_type: one-to-one
        top_signame: uart0_tl
        index: -1
      }
      {
        name: lsio_trigger
        desc:
          '''
          Self-clearing status trigger for the DMA.
          Set when RX or TX FIFOs are past their configured watermarks matching watermark interrupt behaviour.
          '''
        struct: logic
        type: uni
        act: req
        width: 1
        inst_name: uart1
        index: -1
      }
      {
        name: racl_policies
        desc:
          '''
          Incoming RACL policy vector from a racl_ctrl instance.
          The policy selection vector (parameter) selects the policy for each register.
          '''
        struct: racl_policy_vec
        package: top_racl_pkg
        type: uni
        act: rcv
        width: 1
        inst_name: uart1
        index: -1
      }
      {
        name: racl_error
        desc: RACL error log information of this module.
        struct: racl_error_log
        package: top_racl_pkg
        type: uni
        act: req
        width: 1
        inst_name: uart1
        index: -1
      }
      {
        name: tl
        struct: tl
        package: tlul_pkg
        type: req_rsp
        act: rsp
        width: 1
        inst_name: uart1
        default: ""
        end_idx: -1
        top_type: one-to-one
        top_signame: uart1_tl
        index: -1
      }
      {
        name: lsio_trigger
        desc:
          '''
          Self-clearing status trigger for the DMA.
          Set when RX or TX FIFOs are past their configured watermarks matching watermark interrupt behaviour.
          '''
        struct: logic
        type: uni
        act: req
        width: 1
        inst_name: uart2
        index: -1
      }
      {
        name: racl_policies
        desc:
          '''
          Incoming RACL policy vector from a racl_ctrl instance.
          The policy selection vector (parameter) selects the policy for each register.
          '''
        struct: racl_policy_vec
        package: top_racl_pkg
        type: uni
        act: rcv
        width: 1
        inst_name: uart2
        index: -1
      }
      {
        name: racl_error
        desc: RACL error log information of this module.
        struct: racl_error_log
        package: top_racl_pkg
        type: uni
        act: req
        width: 1
        inst_name: uart2
        index: -1
      }
      {
        name: tl
        struct: tl
        package: tlul_pkg
        type: req_rsp
        act: rsp
        width: 1
        inst_name: uart2
        default: ""
        end_idx: -1
        top_type: one-to-one
        top_signame: uart2_tl
        index: -1
      }
      {
        name: lsio_trigger
        desc:
          '''
          Self-clearing status trigger for the DMA.
          Set when RX or TX FIFOs are past their configured watermarks matching watermark interrupt behaviour.
          '''
        struct: logic
        type: uni
        act: req
        width: 1
        inst_name: uart3
        index: -1
      }
      {
        name: racl_policies
        desc:
          '''
          Incoming RACL policy vector from a racl_ctrl instance.
          The policy selection vector (parameter) selects the policy for each register.
          '''
        struct: racl_policy_vec
        package: top_racl_pkg
        type: uni
        act: rcv
        width: 1
        inst_name: uart3
        index: -1
      }
      {
        name: racl_error
        desc: RACL error log information of this module.
        struct: racl_error_log
        package: top_racl_pkg
        type: uni
        act: req
        width: 1
        inst_name: uart3
        index: -1
      }
      {
        name: tl
        struct: tl
        package: tlul_pkg
        type: req_rsp
        act: rsp
        width: 1
        inst_name: uart3
        default: ""
        end_idx: -1
        top_type: one-to-one
        top_signame: uart3_tl
        index: -1
      }
      {
        name: strap_en
        desc:
          '''
          The strap enable signal tells gpio to take a snapshot of the input pins.
          The behaviour of this signal after that event will have no effect.
          '''
        struct: logic
        type: uni
        act: rcv
        width: 1
        default: 1'b0
        inst_name: gpio0
        index: -1
      }
      {
        name: sampled_straps
        desc: This vector contains the sampled strap values.
        struct: gpio_straps
        package: gpio_pkg
        type: uni
        act: req
        width: 1
        default: "'0"
        inst_name: gpio0
        index: -1
      }
      {
        name: racl_policies
        desc:
          '''
          Incoming RACL policy vector from a racl_ctrl instance.
          The policy selection vector (parameter) selects the policy for each register.
          '''
        struct: racl_policy_vec
        package: top_racl_pkg
        type: uni
        act: rcv
        width: 1
        inst_name: gpio0
        index: -1
      }
      {
        name: racl_error
        desc: RACL error log information of this module.
        struct: racl_error_log
        package: top_racl_pkg
        type: uni
        act: req
        width: 1
        inst_name: gpio0
        index: -1
      }
      {
        name: tl
        struct: tl
        package: tlul_pkg
        type: req_rsp
        act: rsp
        width: 1
        inst_name: gpio0
        default: ""
        end_idx: -1
        top_type: one-to-one
        top_signame: gpio0_tl
        index: -1
      }
      {
        name: strap_en
        desc:
          '''
          The strap enable signal tells gpio to take a snapshot of the input pins.
          The behaviour of this signal after that event will have no effect.
          '''
        struct: logic
        type: uni
        act: rcv
        width: 1
        default: 1'b0
        inst_name: gpio1
        index: -1
      }
      {
        name: sampled_straps
        desc: This vector contains the sampled strap values.
        struct: gpio_straps
        package: gpio_pkg
        type: uni
        act: req
        width: 1
        default: "'0"
        inst_name: gpio1
        index: -1
      }
      {
        name: racl_policies
        desc:
          '''
          Incoming RACL policy vector from a racl_ctrl instance.
          The policy selection vector (parameter) selects the policy for each register.
          '''
        struct: racl_policy_vec
        package: top_racl_pkg
        type: uni
        act: rcv
        width: 1
        inst_name: gpio1
        index: -1
      }
      {
        name: racl_error
        desc: RACL error log information of this module.
        struct: racl_error_log
        package: top_racl_pkg
        type: uni
        act: req
        width: 1
        inst_name: gpio1
        index: -1
      }
      {
        name: tl
        struct: tl
        package: tlul_pkg
        type: req_rsp
        act: rsp
        width: 1
        inst_name: gpio1
        default: ""
        end_idx: -1
        top_type: one-to-one
        top_signame: gpio1_tl
        index: -1
      }
      {
        name: ram_cfg_sys2spi
        struct: ram_1r1w_cfg
        package: prim_ram_1r1w_pkg
        type: req_rsp
        act: rsp
        width: 1
        inst_name: spi_device
        default: ""
        top_signame: spi_device_ram_cfg_sys2spi
        index: -1
      }
      {
        name: ram_cfg_spi2sys
        struct: ram_1r1w_cfg
        package: prim_ram_1r1w_pkg
        type: req_rsp
        act: rsp
        width: 1
        inst_name: spi_device
        default: ""
        top_signame: spi_device_ram_cfg_spi2sys
        index: -1
      }
      {
        name: passthrough
        struct: passthrough
        package: spi_device_pkg
        type: req_rsp
        act: req
        width: 1
        inst_name: spi_device
        default: ""
        end_idx: -1
        top_type: one-to-one
        top_signame: spi_device_passthrough
        index: -1
      }
      {
        name: mbist_en
        struct: logic
        type: uni
        act: rcv
        width: 1
        inst_name: spi_device
        index: -1
      }
      {
        name: sck_monitor
        struct: logic
        type: uni
        act: req
        width: 1
        inst_name: spi_device
        index: -1
      }
      {
        name: racl_policies
        desc:
          '''
          Incoming RACL policy vector from a racl_ctrl instance.
          The policy selection vector (parameter) selects the policy for each register.
          '''
        struct: racl_policy_vec
        package: top_racl_pkg
        type: uni
        act: rcv
        width: 1
        inst_name: spi_device
        index: -1
      }
      {
        name: racl_error
        desc: RACL error log information of this module.
        struct: racl_error_log
        package: top_racl_pkg
        type: uni
        act: req
        width: 1
        inst_name: spi_device
        index: -1
      }
      {
        name: tl
        struct: tl
        package: tlul_pkg
        type: req_rsp
        act: rsp
        width: 1
        inst_name: spi_device
        default: ""
        end_idx: -1
        top_type: one-to-one
        top_signame: spi_device_tl
        index: -1
      }
      {
        name: ram_cfg
        struct: ram_1p_cfg
        package: prim_ram_1p_pkg
        type: req_rsp
        act: rsp
        width: 1
        inst_name: i2c0
        default: ""
        top_signame: i2c0_ram_cfg
        index: -1
      }
      {
        name: lsio_trigger
        desc:
          '''
          Self-clearing status trigger for the DMA.
          Set when RX TX FIFO is past their configured watermark matching watermark interrupt behaviour.
          '''
        struct: logic
        type: uni
        act: req
        width: 1
        inst_name: i2c0
        index: -1
      }
      {
        name: racl_policies
        desc:
          '''
          Incoming RACL policy vector from a racl_ctrl instance.
          The policy selection vector (parameter) selects the policy for each register.
          '''
        struct: racl_policy_vec
        package: top_racl_pkg
        type: uni
        act: rcv
        width: 1
        inst_name: i2c0
        index: -1
      }
      {
        name: racl_error
        desc: RACL error log information of this module.
        struct: racl_error_log
        package: top_racl_pkg
        type: uni
        act: req
        width: 1
        inst_name: i2c0
        index: -1
      }
      {
        name: tl
        struct: tl
        package: tlul_pkg
        type: req_rsp
        act: rsp
        width: 1
        inst_name: i2c0
        default: ""
        end_idx: -1
        top_type: one-to-one
        top_signame: i2c0_tl
        index: -1
      }
      {
        name: ram_cfg
        struct: ram_1p_cfg
        package: prim_ram_1p_pkg
        type: req_rsp
        act: rsp
        width: 1
        inst_name: i2c1
        default: ""
        top_signame: i2c1_ram_cfg
        index: -1
      }
      {
        name: lsio_trigger
        desc:
          '''
          Self-clearing status trigger for the DMA.
          Set when RX TX FIFO is past their configured watermark matching watermark interrupt behaviour.
          '''
        struct: logic
        type: uni
        act: req
        width: 1
        inst_name: i2c1
        index: -1
      }
      {
        name: racl_policies
        desc:
          '''
          Incoming RACL policy vector from a racl_ctrl instance.
          The policy selection vector (parameter) selects the policy for each register.
          '''
        struct: racl_policy_vec
        package: top_racl_pkg
        type: uni
        act: rcv
        width: 1
        inst_name: i2c1
        index: -1
      }
      {
        name: racl_error
        desc: RACL error log information of this module.
        struct: racl_error_log
        package: top_racl_pkg
        type: uni
        act: req
        width: 1
        inst_name: i2c1
        index: -1
      }
      {
        name: tl
        struct: tl
        package: tlul_pkg
        type: req_rsp
        act: rsp
        width: 1
        inst_name: i2c1
        default: ""
        end_idx: -1
        top_type: one-to-one
        top_signame: i2c1_tl
        index: -1
      }
      {
        name: ram_cfg
        struct: ram_1p_cfg
        package: prim_ram_1p_pkg
        type: req_rsp
        act: rsp
        width: 1
        inst_name: i2c2
        default: ""
        top_signame: i2c2_ram_cfg
        index: -1
      }
      {
        name: lsio_trigger
        desc:
          '''
          Self-clearing status trigger for the DMA.
          Set when RX TX FIFO is past their configured watermark matching watermark interrupt behaviour.
          '''
        struct: logic
        type: uni
        act: req
        width: 1
        inst_name: i2c2
        index: -1
      }
      {
        name: racl_policies
        desc:
          '''
          Incoming RACL policy vector from a racl_ctrl instance.
          The policy selection vector (parameter) selects the policy for each register.
          '''
        struct: racl_policy_vec
        package: top_racl_pkg
        type: uni
        act: rcv
        width: 1
        inst_name: i2c2
        index: -1
      }
      {
        name: racl_error
        desc: RACL error log information of this module.
        struct: racl_error_log
        package: top_racl_pkg
        type: uni
        act: req
        width: 1
        inst_name: i2c2
        index: -1
      }
      {
        name: tl
        struct: tl
        package: tlul_pkg
        type: req_rsp
        act: rsp
        width: 1
        inst_name: i2c2
        default: ""
        end_idx: -1
        top_type: one-to-one
        top_signame: i2c2_tl
        index: -1
      }
      {
        name: rstdet_enable
        desc: Enables the SCL/SDA inputs of the Target Reset Detector in the secondary partition; deasserted while the Target is disconnected from the bus.
        struct: logic
        type: uni
        act: req
        width: 1
        inst_name: i3c0
        default: ""
        package: ""
        end_idx: -1
        top_type: broadcast
        top_signame: i3c0_rstdet_enable
        index: -1
        external: true
        conn_type: false
      }
      {
        name: rstdet_enable
        desc: Enables the SCL/SDA inputs of the Target Reset Detector; deasserted while the Target is disconnected from the bus.
        struct: logic
        type: uni
        act: rcv
        width: 1
        partition: secondary
        inst_name: i3c0
        default: ""
        package: ""
        domain: Aon
        top_signame: i3c0_rstdet_enable
        index: -1
        external: true
        conn_type: false
      }
      {
        name: rstdet
        desc: Control and status interface to the Target Reset Detector in the secondary partition.
        struct: i3c_rstdet
        package: i3c_pkg
        type: req_rsp
        act: req
        width: 1
        inst_name: i3c0
        default: ""
        end_idx: -1
        top_type: one-to-one
        top_signame: i3c0_rstdet
        index: -1
        external: true
        conn_type: false
      }
      {
        name: rstdet
        desc: Control and status interface of the Target Reset Detector to the primary partition.
        struct: i3c_rstdet
        package: i3c_pkg
        type: req_rsp
        act: rsp
        width: 1
        partition: secondary
        inst_name: i3c0
        default: ""
        domain: Aon
        top_signame: i3c0_rstdet
        index: -1
        external: true
        conn_type: false
      }
      {
        name: rstdet_wkup_req
        desc: Wake-up request on detection of the Target Reset Pattern.
        struct: logic
        type: uni
        act: req
        width: 1
        partition: secondary
        inst_name: i3c0
        default: ""
        package: ""
        domain: Aon
        top_signame: pwrmgr_wakeups
        index: 0
      }
      {
        name: rstdet_target_rst
        desc: Reset request for the I3C peripheral on detection of the Target Reset Pattern.
        struct: logic
        type: uni
        act: req
        width: 1
        partition: secondary
        inst_name: i3c0
        index: -1
      }
      {
        name: mbist_en
        desc: Memory built-in self-test enable (unused).
        struct: logic
        type: uni
        act: rcv
        width: 1
        inst_name: i3c0
        index: -1
      }
      {
        name: scl_hk_en
        desc: I3C Controller clock High-keeper enable output
        struct: logic
        type: uni
        act: req
        width: 1
        inst_name: i3c0
        index: -1
      }
      {
        name: sda_hk_en
        desc: I3C Controller data High-keeper enable output
        struct: logic
        type: uni
        act: req
        width: 1
        inst_name: i3c0
        index: -1
      }
      {
        name: ctrl_scl_pu_en
        desc: I3C Controller clock Pullup enable output
        struct: logic
        type: uni
        act: req
        width: 1
        inst_name: i3c0
        index: -1
      }
      {
        name: ram_cfg
        desc: RAM configuration of the message buffer memory.
        struct: ram_1p_cfg
        package: prim_ram_1p_pkg
        type: req_rsp
        act: rsp
        width: 1
        inst_name: i3c0
        default: ""
        top_signame: i3c0_ram_cfg
        index: -1
      }
      {
        name: dat_cfg
        desc: RAM configuration of the Device Address Table (DAT) memory.
        struct: ram_1p_cfg
        package: prim_ram_1p_pkg
        type: req_rsp
        act: rsp
        width: 1
        inst_name: i3c0
        default: ""
        top_signame: i3c0_dat_cfg
        index: -1
      }
      {
        name: dct_cfg
        desc: RAM configuration of the Device Characteristics Table (DCT) memory.
        struct: ram_1p_cfg
        package: prim_ram_1p_pkg
        type: req_rsp
        act: rsp
        width: 1
        inst_name: i3c0
        default: ""
        top_signame: i3c0_dct_cfg
        index: -1
      }
      {
        name: racl_policies
        desc:
          '''
          Incoming RACL policy vector from a racl_ctrl instance.
          The policy selection vector (parameter) selects the policy for each register.
          '''
        struct: racl_policy_vec
        package: top_racl_pkg
        type: uni
        act: rcv
        width: 1
        inst_name: i3c0
        index: -1
      }
      {
        name: racl_error
        desc: RACL error log information of this module.
        struct: racl_error_log
        package: top_racl_pkg
        type: uni
        act: req
        width: 1
        inst_name: i3c0
        index: -1
      }
      {
        name: tl
        struct: tl
        package: tlul_pkg
        type: req_rsp
        act: rsp
        width: 1
        inst_name: i3c0
        default: ""
        end_idx: -1
        top_type: one-to-one
        top_signame: i3c0_tl
        index: -1
      }
      {
        name: rstdet_enable
        desc: Enables the SCL/SDA inputs of the Target Reset Detector in the secondary partition; deasserted while the Target is disconnected from the bus.
        struct: logic
        type: uni
        act: req
        width: 1
        inst_name: i3c1
        default: ""
        package: ""
        end_idx: -1
        top_type: broadcast
        top_signame: i3c1_rstdet_enable
        index: -1
      }
      {
        name: rstdet_enable
        desc: Enables the SCL/SDA inputs of the Target Reset Detector; deasserted while the Target is disconnected from the bus.
        struct: logic
        type: uni
        act: rcv
        width: 1
        partition: secondary
        inst_name: i3c1
        default: ""
        package: ""
        domain: Main
        top_signame: i3c1_rstdet_enable
        index: -1
      }
      {
        name: rstdet
        desc: Control and status interface to the Target Reset Detector in the secondary partition.
        struct: i3c_rstdet
        package: i3c_pkg
        type: req_rsp
        act: req
        width: 1
        inst_name: i3c1
        default: ""
        end_idx: -1
        top_type: one-to-one
        top_signame: i3c1_rstdet
        index: -1
      }
      {
        name: rstdet
        desc: Control and status interface of the Target Reset Detector to the primary partition.
        struct: i3c_rstdet
        package: i3c_pkg
        type: req_rsp
        act: rsp
        width: 1
        partition: secondary
        inst_name: i3c1
        default: ""
        domain: Main
        top_signame: i3c1_rstdet
        index: -1
      }
      {
        name: rstdet_wkup_req
        desc: Wake-up request on detection of the Target Reset Pattern.
        struct: logic
        type: uni
        act: req
        width: 1
        partition: secondary
        inst_name: i3c1
        default: ""
        package: ""
        domain: Main
        top_signame: pwrmgr_wakeups
        index: -1
        external: true
        conn_type: false
      }
      {
        name: rstdet_target_rst
        desc: Reset request for the I3C peripheral on detection of the Target Reset Pattern.
        struct: logic
        type: uni
        act: req
        width: 1
        partition: secondary
        inst_name: i3c1
        index: -1
      }
      {
        name: mbist_en
        desc: Memory built-in self-test enable (unused).
        struct: logic
        type: uni
        act: rcv
        width: 1
        inst_name: i3c1
        index: -1
      }
      {
        name: scl_hk_en
        desc: I3C Controller clock High-keeper enable output
        struct: logic
        type: uni
        act: req
        width: 1
        inst_name: i3c1
        index: -1
      }
      {
        name: sda_hk_en
        desc: I3C Controller data High-keeper enable output
        struct: logic
        type: uni
        act: req
        width: 1
        inst_name: i3c1
        index: -1
      }
      {
        name: ctrl_scl_pu_en
        desc: I3C Controller clock Pullup enable output
        struct: logic
        type: uni
        act: req
        width: 1
        inst_name: i3c1
        index: -1
      }
      {
        name: ram_cfg
        desc: RAM configuration of the message buffer memory.
        struct: ram_1p_cfg
        package: prim_ram_1p_pkg
        type: req_rsp
        act: rsp
        width: 1
        inst_name: i3c1
        default: ""
        top_signame: i3c1_ram_cfg
        index: -1
      }
      {
        name: dat_cfg
        desc: RAM configuration of the Device Address Table (DAT) memory.
        struct: ram_1p_cfg
        package: prim_ram_1p_pkg
        type: req_rsp
        act: rsp
        width: 1
        inst_name: i3c1
        default: ""
        top_signame: i3c1_dat_cfg
        index: -1
      }
      {
        name: dct_cfg
        desc: RAM configuration of the Device Characteristics Table (DCT) memory.
        struct: ram_1p_cfg
        package: prim_ram_1p_pkg
        type: req_rsp
        act: rsp
        width: 1
        inst_name: i3c1
        default: ""
        top_signame: i3c1_dct_cfg
        index: -1
      }
      {
        name: racl_policies
        desc:
          '''
          Incoming RACL policy vector from a racl_ctrl instance.
          The policy selection vector (parameter) selects the policy for each register.
          '''
        struct: racl_policy_vec
        package: top_racl_pkg
        type: uni
        act: rcv
        width: 1
        inst_name: i3c1
        index: -1
      }
      {
        name: racl_error
        desc: RACL error log information of this module.
        struct: racl_error_log
        package: top_racl_pkg
        type: uni
        act: req
        width: 1
        inst_name: i3c1
        index: -1
      }
      {
        name: tl
        struct: tl
        package: tlul_pkg
        type: req_rsp
        act: rsp
        width: 1
        inst_name: i3c1
        default: ""
        end_idx: -1
        top_type: one-to-one
        top_signame: i3c1_tl
        index: -1
      }
      {
        name: racl_policies
        desc:
          '''
          Incoming RACL policy vector from a racl_ctrl instance.
          The policy selection vector (parameter) selects the policy for each register.
          '''
        struct: racl_policy_vec
        package: top_racl_pkg
        type: uni
        act: rcv
        width: 1
        inst_name: rv_timer
        index: -1
      }
      {
        name: racl_error
        desc: RACL error log information of this module.
        struct: racl_error_log
        package: top_racl_pkg
        type: uni
        act: req
        width: 1
        inst_name: rv_timer
        index: -1
      }
      {
        name: tl
        struct: tl
        package: tlul_pkg
        type: req_rsp
        act: rsp
        width: 1
        inst_name: rv_timer
        default: ""
        end_idx: -1
        top_type: one-to-one
        top_signame: rv_timer_tl
        index: -1
      }
      {
        name: edn
        desc: Entropy request to the entropy distribution network for LFSR reseeding and ephemeral key derivation.
        struct: edn
        package: edn_pkg
        type: req_rsp
        act: req
        width: 1
        inst_name: otp_ctrl
        default: ""
        domain: Main
        top_signame: edn0_edn
        index: 1
      }
      {
        name: pwr_otp
        desc: Initialization request/acknowledge from/to power manager.
        struct: pwr_otp
        package: pwrmgr_pkg
        type: req_rsp
        act: rsp
        width: 1
        default: "'0"
        inst_name: otp_ctrl
        domain: Main
        top_signame: pwrmgr_pwr_otp
        index: -1
        external: true
        conn_type: false
      }
      {
        name: lc_otp_program
        desc: Life cycle state transition interface.
        struct: lc_otp_program
        package: otp_ctrl_pkg
        type: req_rsp
        act: rsp
        width: 1
        default: "'0"
        inst_name: otp_ctrl
        domain: Main
        top_signame: lc_ctrl_lc_otp_program
        index: -1
      }
      {
        name: otp_lc_data
        desc:
          '''
          Life cycle state output holding the current life cycle state,
          the value of the transition counter and the tokens needed for life cycle transitions.
          '''
        struct: otp_lc_data
        package: otp_ctrl_pkg
        type: uni
        act: req
        width: 1
        default: "'0"
        inst_name: otp_ctrl
        end_idx: -1
        top_type: broadcast
        top_signame: otp_ctrl_otp_lc_data
        index: -1
      }
      {
        name: lc_escalate_en
        desc:
          '''
          Life cycle escalation enable coming from life cycle controller.
          This signal moves all FSMs within OTP into the error state.
          '''
        struct: lc_tx
        package: lc_ctrl_pkg
        type: uni
        act: rcv
        width: 1
        default: lc_ctrl_pkg::Off
        inst_name: otp_ctrl
        domain: Main
        top_signame: lc_ctrl_lc_escalate_en
        index: -1
      }
      {
        name: lc_creator_seed_sw_rw_en
        desc:
          '''
          Provision enable qualifier coming from life cycle controller.
          This signal enables SW read / write access to the RMA_TOKEN and CREATOR_ROOT_KEY_SHARE0 and CREATOR_ROOT_KEY_SHARE1.
          '''
        struct: lc_tx
        package: lc_ctrl_pkg
        type: uni
        act: rcv
        width: 1
        default: lc_ctrl_pkg::Off
        inst_name: otp_ctrl
        domain: Main
        top_signame: lc_ctrl_lc_creator_seed_sw_rw_en
        index: -1
      }
      {
        name: lc_owner_seed_sw_rw_en
        desc:
          '''
          Provision enable qualifier coming from life cycle controller.
          This signal enables SW read / write access to the OWNER_SEED.
          '''
        struct: lc_tx
        package: lc_ctrl_pkg
        type: uni
        act: rcv
        width: 1
        default: lc_ctrl_pkg::Off
        inst_name: otp_ctrl
        index: -1
      }
      {
        name: lc_seed_hw_rd_en
        desc:
          '''
          Seed read enable coming from life cycle controller.
          This signal enables HW read access to the CREATOR_ROOT_KEY_SHARE0 and CREATOR_ROOT_KEY_SHARE1.
          '''
        struct: lc_tx
        package: lc_ctrl_pkg
        type: uni
        act: rcv
        width: 1
        default: lc_ctrl_pkg::Off
        inst_name: otp_ctrl
        domain: Main
        top_signame: lc_ctrl_lc_seed_hw_rd_en
        index: -1
      }
      {
        name: lc_rma_state
        desc:
          '''
          This signal states whether the current life cycle is RMA.
          It is used to enable SW read access to (read-locked) partitions in the RMA state.
          '''
        struct: lc_tx
        package: lc_ctrl_pkg
        type: uni
        act: rcv
        width: 1
        default: lc_ctrl_pkg::Off
        inst_name: otp_ctrl
        domain: Main
        top_signame: lc_ctrl_lc_rma_state
        index: -1
      }
      {
        name: lc_check_byp_en
        desc:
          '''
          Life cycle partition check bypass signal.
          This signal causes the life cycle partition to bypass consistency checks during life cycle state transitions in order to prevent spurious consistency check failures.
          '''
        struct: lc_tx
        package: lc_ctrl_pkg
        type: uni
        act: rcv
        width: 1
        default: lc_ctrl_pkg::Off
        inst_name: otp_ctrl
        domain: Main
        top_signame: lc_ctrl_lc_check_byp_en
        index: -1
      }
      {
        name: keymgr_creator_root_key
        desc: Key output to the key manager holding CREATOR_ROOT_KEY_SHARE0 and CREATOR_ROOT_KEY_SHARE1.
        struct: keymgr_dpe_creator_root_key
        package: keymgr_dpe_pkg
        type: uni
        act: req
        width: 1
        default: "'0"
        inst_name: otp_ctrl
        end_idx: -1
        top_type: broadcast
        top_signame: otp_ctrl_keymgr_creator_root_key
        index: -1
      }
      {
        name: keymgr_creator_seed
        desc: Creator seed output to the key manager
        struct: keymgr_dpe_creator_seed
        package: keymgr_dpe_pkg
        type: uni
        act: req
        width: 1
        default: "'0"
        inst_name: otp_ctrl
        index: -1
      }
      {
        name: keymgr_owner_seed
        desc: Owner seed output to the key manager
        struct: keymgr_dpe_owner_seed
        package: keymgr_dpe_pkg
        type: uni
        act: req
        width: 1
        default: "'0"
        inst_name: otp_ctrl
        index: -1
      }
      {
        name: nvm_otp_key
        desc: Key derivation interface for NVM scrambling.
        struct: nvm_otp_key
        package: otp_ctrl_pkg
        type: req_rsp
        act: rsp
        width: 1
        default: "'0"
        inst_name: otp_ctrl
        domain: Main
        top_signame: rram_ctrl_otp_key
        index: -1
      }
      {
        name: sram_otp_key
        desc: Array with key derivation interfaces for SRAM scrambling devices.
        struct: sram_otp_key
        package: otp_ctrl_pkg
        type: req_rsp
        act: rsp
        width: 5
        default: "'0"
        inst_name: otp_ctrl
        end_idx: -1
        top_type: one-to-N
        top_signame: otp_ctrl_sram_otp_key
        index: 2
        external: true
        conn_type: true
      }
      {
        name: otbn_otp_key
        desc: Key derivation interface for OTBN scrambling devices.
        struct: otbn_otp_key
        package: otp_ctrl_pkg
        type: req_rsp
        act: rsp
        width: 1
        default: "'0"
        inst_name: otp_ctrl
        end_idx: -1
        top_type: one-to-one
        top_signame: otp_ctrl_otbn_otp_key
        index: -1
      }
      {
        name: otp_broadcast
        desc: Output of the HW partitions with breakout data types.
        struct: otp_broadcast
        package: otp_ctrl_part_pkg
        type: uni
        act: req
        width: 1
        default: "'0"
        inst_name: otp_ctrl
        top_signame: otp_ctrl_otp_broadcast
        index: -1
      }
      {
        name: otp_macro
        desc: Data interface for the OTP macro.
        struct: otp_ctrl_macro
        package: otp_ctrl_macro_pkg
        type: req_rsp
        act: req
        width: 1
        default: "'0"
        inst_name: otp_ctrl
        end_idx: -1
        top_type: one-to-one
        top_signame: otp_ctrl_otp_macro
        index: -1
      }
      {
        name: core_tl
        struct: tl
        package: tlul_pkg
        type: req_rsp
        act: rsp
        width: 1
        inst_name: otp_ctrl
        default: ""
        end_idx: -1
        top_type: one-to-one
        top_signame: otp_ctrl_core_tl
        index: -1
      }
      {
        name: jtag
        struct: jtag
        package: jtag_pkg
        type: req_rsp
        act: rsp
        width: 1
        inst_name: lc_ctrl
        default: ""
        domain: Main
        top_signame: pinmux_lc_jtag
        index: -1
        external: true
        conn_type: false
      }
      {
        name: esc_scrap_state0_tx
        struct: esc_tx
        package: prim_esc_pkg
        type: uni
        act: rcv
        width: 1
        inst_name: lc_ctrl
        default: ""
        domain: Main
        top_signame: alert_handler_esc_tx
        index: 1
      }
      {
        name: esc_scrap_state0_rx
        struct: esc_rx
        package: prim_esc_pkg
        type: uni
        act: req
        width: 1
        inst_name: lc_ctrl
        default: ""
        domain: Main
        top_signame: alert_handler_esc_rx
        index: 1
      }
      {
        name: esc_scrap_state1_tx
        struct: esc_tx
        package: prim_esc_pkg
        type: uni
        act: rcv
        width: 1
        inst_name: lc_ctrl
        default: ""
        domain: Main
        top_signame: alert_handler_esc_tx
        index: 2
      }
      {
        name: esc_scrap_state1_rx
        struct: esc_rx
        package: prim_esc_pkg
        type: uni
        act: req
        width: 1
        inst_name: lc_ctrl
        default: ""
        domain: Main
        top_signame: alert_handler_esc_rx
        index: 2
      }
      {
        name: pwr_lc
        struct: pwr_lc
        package: lc_ctrl_pkg
        type: req_rsp
        act: rsp
        width: 1
        inst_name: lc_ctrl
        default: ""
        domain: Main
        top_signame: pwrmgr_pwr_lc
        index: -1
        external: true
        conn_type: false
      }
      {
        name: lc_otp_vendor_test
        struct: otp_test
        package: otp_macro_pkg
        type: req_rsp
        act: req
        width: 1
        default: "'0"
        inst_name: lc_ctrl
        index: -1
      }
      {
        name: otp_lc_data
        struct: otp_lc_data
        package: otp_ctrl_pkg
        type: uni
        act: rcv
        width: 1
        default: otp_ctrl_pkg::OTP_LC_DATA_DEFAULT
        inst_name: lc_ctrl
        domain: Main
        top_signame: otp_ctrl_otp_lc_data
        index: -1
      }
      {
        name: lc_otp_program
        struct: lc_otp_program
        package: otp_ctrl_pkg
        type: req_rsp
        act: req
        width: 1
        default: "'0"
        inst_name: lc_ctrl
        end_idx: -1
        top_type: one-to-one
        top_signame: lc_ctrl_lc_otp_program
        index: -1
      }
      {
        name: kmac_data
        struct: app
        package: kmac_pkg
        type: req_rsp
        act: req
        width: 1
        default: "'0"
        inst_name: lc_ctrl
        domain: Main
        top_signame: kmac_app
        index: 1
      }
      {
        name: lc_init_done
        desc:
          '''
          Indicates that life cycle initialization is complete and the broadcast signals are valid; see `INIT_DONE` in the Theory of Operation doc for details.
          This signal is Off while lc_ctrl is in reset.
          Once On, it stays On until lc_ctrl is reset.
          '''
        struct: lc_tx
        package: lc_ctrl_pkg
        type: uni
        act: req
        width: 1
        default: lc_ctrl_pkg::Off
        inst_name: lc_ctrl
        end_idx: -1
        top_type: broadcast
        top_signame: lc_ctrl_lc_init_done
        index: -1
      }
      {
        name: lc_raw_test_rma
        struct: lc_tx
        package: lc_ctrl_pkg
        type: uni
        act: req
        width: 1
        default: lc_ctrl_pkg::Off
        inst_name: lc_ctrl
        index: -1
      }
      {
        name: lc_dft_en
        struct: lc_tx
        package: lc_ctrl_pkg
        type: uni
        act: req
        width: 1
        default: lc_ctrl_pkg::Off
        inst_name: lc_ctrl
        end_idx: -1
        top_type: broadcast
        top_signame: lc_ctrl_lc_dft_en
        index: -1
        external: true
        conn_type: true
      }
      {
        name: lc_nvm_debug_en
        struct: lc_tx
        package: lc_ctrl_pkg
        type: uni
        act: req
        width: 1
        default: lc_ctrl_pkg::Off
        inst_name: lc_ctrl
        end_idx: -1
        top_type: broadcast
        top_signame: lc_ctrl_lc_nvm_debug_en
        index: -1
        external: true
        conn_type: true
      }
      {
        name: lc_hw_debug_clr
        desc:
          '''
          Clear HW debug functionality; see `HW_DEBUG_CLR` in the Theory of Operation doc for details.

          This signal is used to clear stored copies of `lc_hw_debug_en` when HW debug functionality gets disabled outside a reset of `lc_ctrl`.
          This signal is On in the SCRAP, INVALID, POST_TRANSITION and ESCALATION states, in which `lc_hw_debug_en` is Off.
          Once On, it remains On until lc_ctrl is reset.
          Flops storing the value of `lc_hw_debug_en` (see below) must be cleared whenever this signal is not Off.
          '''
        struct: lc_tx
        package: lc_ctrl_pkg
        type: uni
        act: req
        width: 1
        default: lc_ctrl_pkg::Off
        inst_name: lc_ctrl
        end_idx: -1
        top_type: broadcast
        top_signame: lc_ctrl_lc_hw_debug_clr
        index: -1
        external: true
        conn_type: true
      }
      {
        name: lc_hw_debug_en
        desc:
          '''
          Enable HW debug functionality; see `HW_DEBUG_EN` in the Theory of Operation doc for details.

          This signal is Off while lc_ctrl is in reset.
          In order to prevent a JTAG disconnect during non-debug-module (NDM) reset, this signal should be flopped outside the NDM reset domain.
          Such a flop must be cleared whenever `lc_hw_debug_clr` is not Off; see above.
          '''
        struct: lc_tx
        package: lc_ctrl_pkg
        type: uni
        act: req
        width: 1
        default: lc_ctrl_pkg::Off
        inst_name: lc_ctrl
        end_idx: -1
        top_type: broadcast
        top_signame: lc_ctrl_lc_hw_debug_en
        index: -1
        external: true
        conn_type: true
      }
      {
        name: lc_cpu_en
        struct: lc_tx
        package: lc_ctrl_pkg
        type: uni
        act: req
        width: 1
        default: lc_ctrl_pkg::Off
        inst_name: lc_ctrl
        end_idx: -1
        top_type: broadcast
        top_signame: lc_ctrl_lc_cpu_en
        index: -1
      }
      {
        name: lc_keymgr_en
        struct: lc_tx
        package: lc_ctrl_pkg
        type: uni
        act: req
        width: 1
        default: lc_ctrl_pkg::Off
        inst_name: lc_ctrl
        end_idx: -1
        top_type: broadcast
        top_signame: lc_ctrl_lc_keymgr_en
        index: -1
      }
      {
        name: lc_escalate_en
        struct: lc_tx
        package: lc_ctrl_pkg
        type: uni
        act: req
        width: 1
        default: lc_ctrl_pkg::Off
        inst_name: lc_ctrl
        end_idx: -1
        top_type: broadcast
        top_signame: lc_ctrl_lc_escalate_en
        index: -1
        external: true
        conn_type: true
      }
      {
        name: lc_clk_byp_req
        struct: lc_tx
        package: lc_ctrl_pkg
        type: uni
        act: req
        width: 1
        default: lc_ctrl_pkg::Off
        inst_name: lc_ctrl
        end_idx: -1
        top_type: broadcast
        top_signame: lc_ctrl_lc_clk_byp_req
        index: -1
        external: true
        conn_type: false
      }
      {
        name: lc_clk_byp_ack
        struct: lc_tx
        package: lc_ctrl_pkg
        type: uni
        act: rcv
        width: 1
        default: lc_ctrl_pkg::Off
        inst_name: lc_ctrl
        end_idx: -1
        top_type: broadcast
        top_signame: lc_ctrl_lc_clk_byp_ack
        index: -1
        external: true
        conn_type: false
      }
      {
        name: lc_nvm_rma_req
        struct: lc_tx
        package: lc_ctrl_pkg
        type: uni
        act: req
        width: 1
        default: lc_ctrl_pkg::Off
        inst_name: lc_ctrl
        end_idx: -1
        top_type: broadcast
        top_signame: lc_ctrl_lc_nvm_rma_req
        index: -1
      }
      {
        name: lc_nvm_rma_ack
        struct: lc_tx
        package: lc_ctrl_pkg
        type: uni
        act: rcv
        width: 2
        default: lc_ctrl_pkg::On
        inst_name: lc_ctrl
        end_idx: -1
        top_type: one-to-N
        top_signame: lc_ctrl_lc_nvm_rma_ack
        index: -1
      }
      {
        name: lc_nvm_rma_seed
        struct: lc_nvm_rma_seed
        package: lc_ctrl_pkg
        type: uni
        act: req
        width: 1
        default: "'0"
        inst_name: lc_ctrl
        end_idx: -1
        top_type: broadcast
        top_signame: lc_ctrl_lc_nvm_rma_seed
        index: -1
      }
      {
        name: lc_check_byp_en
        struct: lc_tx
        package: lc_ctrl_pkg
        type: uni
        act: req
        width: 1
        default: lc_ctrl_pkg::Off
        inst_name: lc_ctrl
        end_idx: -1
        top_type: broadcast
        top_signame: lc_ctrl_lc_check_byp_en
        index: -1
        external: true
        conn_type: true
      }
      {
        name: lc_creator_seed_sw_rw_en
        struct: lc_tx
        package: lc_ctrl_pkg
        type: uni
        act: req
        width: 1
        default: lc_ctrl_pkg::Off
        inst_name: lc_ctrl
        end_idx: -1
        top_type: broadcast
        top_signame: lc_ctrl_lc_creator_seed_sw_rw_en
        index: -1
      }
      {
        name: lc_owner_seed_sw_rw_en
        struct: lc_tx
        package: lc_ctrl_pkg
        type: uni
        act: req
        width: 1
        default: lc_ctrl_pkg::Off
        inst_name: lc_ctrl
        end_idx: -1
        top_type: broadcast
        top_signame: lc_ctrl_lc_owner_seed_sw_rw_en
        index: -1
      }
      {
        name: lc_iso_part_sw_rd_en
        struct: lc_tx
        package: lc_ctrl_pkg
        type: uni
        act: req
        width: 1
        default: lc_ctrl_pkg::Off
        inst_name: lc_ctrl
        end_idx: -1
        top_type: broadcast
        top_signame: lc_ctrl_lc_iso_part_sw_rd_en
        index: -1
      }
      {
        name: lc_iso_part_sw_wr_en
        struct: lc_tx
        package: lc_ctrl_pkg
        type: uni
        act: req
        width: 1
        default: lc_ctrl_pkg::Off
        inst_name: lc_ctrl
        end_idx: -1
        top_type: broadcast
        top_signame: lc_ctrl_lc_iso_part_sw_wr_en
        index: -1
      }
      {
        name: lc_seed_hw_rd_en
        struct: lc_tx
        package: lc_ctrl_pkg
        type: uni
        act: req
        width: 1
        default: lc_ctrl_pkg::Off
        inst_name: lc_ctrl
        end_idx: -1
        top_type: broadcast
        top_signame: lc_ctrl_lc_seed_hw_rd_en
        index: -1
      }
      {
        name: lc_rma_state
        struct: lc_tx
        package: lc_ctrl_pkg
        type: uni
        act: req
        width: 1
        default: lc_ctrl_pkg::Off
        inst_name: lc_ctrl
        end_idx: -1
        top_type: broadcast
        top_signame: lc_ctrl_lc_rma_state
        index: -1
      }
      {
        name: lc_keymgr_div
        struct: lc_keymgr_div
        package: lc_ctrl_pkg
        type: uni
        act: req
        width: 1
        default: "'0"
        inst_name: lc_ctrl
        end_idx: -1
        top_type: broadcast
        top_signame: lc_ctrl_lc_keymgr_div
        index: -1
      }
      {
        name: otp_device_id
        struct: otp_device_id
        package: otp_ctrl_pkg
        type: uni
        act: rcv
        width: 1
        default: "'0"
        inst_name: lc_ctrl
        top_signame: lc_ctrl_otp_device_id
        index: -1
      }
      {
        name: otp_manuf_state
        struct: otp_manuf_state
        package: otp_ctrl_pkg
        type: uni
        act: rcv
        width: 1
        default: "'0"
        inst_name: lc_ctrl
        top_signame: lc_ctrl_otp_manuf_state
        index: -1
      }
      {
        name: hw_rev
        struct: lc_hw_rev
        package: lc_ctrl_pkg
        type: uni
        act: req
        width: 1
        default: "'0"
        inst_name: lc_ctrl
        index: -1
      }
      {
        name: strap_en_override
        desc:
          '''
          This signal transitions from 0 -> 1 by the lc_ctrl manager after volatile RAW_UNLOCK in order to re-sample the HW straps.
          The signal stays at 1 until reset.
          Note that this is only used in test chips when SecVolatileRawUnlockEn = 1.
          Otherwise this signal is tied off to 0.
          '''
        struct: logic
        type: uni
        act: req
        width: 1
        default: 1'b0
        inst_name: lc_ctrl
        package: ""
        end_idx: -1
        top_type: broadcast
        top_signame: lc_ctrl_strap_en_override
        index: -1
        external: true
        conn_type: false
      }
      {
        name: regs_tl
        struct: tl
        package: tlul_pkg
        type: req_rsp
        act: rsp
        width: 1
        inst_name: lc_ctrl
        default: ""
        end_idx: -1
        top_type: one-to-one
        top_signame: lc_ctrl_regs_tl
        index: -1
      }
      {
        name: dmi_tl
        struct: tl
        package: tlul_pkg
        type: req_rsp
        act: rsp
        width: 1
        inst_name: lc_ctrl
        index: -1
      }
      {
        name: crashdump
        struct: alert_crashdump
        package: alert_handler_pkg
        type: uni
        act: req
        width: 1
        inst_name: alert_handler
        default: ""
        end_idx: -1
        top_type: broadcast
        top_signame: alert_handler_crashdump
        index: -1
        external: true
        conn_type: false
      }
      {
        name: edn
        struct: edn
        package: edn_pkg
        type: req_rsp
        act: req
        width: 1
        inst_name: alert_handler
        default: ""
        domain: Main
        top_signame: edn0_edn
        index: 4
      }
      {
        name: esc_rx
        struct: esc_rx
        package: prim_esc_pkg
        type: uni
        act: rcv
        width: 4
        inst_name: alert_handler
        default: ""
        end_idx: -1
        top_type: one-to-N
        top_signame: alert_handler_esc_rx
        index: 3
        external: true
        conn_type: true
      }
      {
        name: esc_tx
        struct: esc_tx
        package: prim_esc_pkg
        type: uni
        act: req
        width: 4
        inst_name: alert_handler
        default: ""
        end_idx: -1
        top_type: one-to-N
        top_signame: alert_handler_esc_tx
        index: 3
        external: true
        conn_type: true
      }
      {
        name: tl
        struct: tl
        package: tlul_pkg
        type: req_rsp
        act: rsp
        width: 1
        inst_name: alert_handler
        default: ""
        end_idx: -1
        top_type: one-to-one
        top_signame: alert_handler_tl
        index: -1
      }
      {
        name: passthrough
        struct: passthrough
        package: spi_device_pkg
        type: req_rsp
        act: rsp
        width: 1
        inst_name: spi_host0
        default: ""
        domain: Main
        top_signame: spi_device_passthrough
        index: -1
      }
      {
        name: lsio_trigger
        desc:
          '''
          Self-clearing status trigger for the DMA.
          Set when RX or TX FIFOs are past their configured watermarks matching watermark interrupt behaviour.
          '''
        struct: logic
        type: uni
        act: req
        width: 1
        inst_name: spi_host0
        index: -1
      }
      {
        name: racl_policies
        desc:
          '''
          Incoming RACL policy vector from a racl_ctrl instance.
          The policy selection vector (parameter) selects the policy for each register.
          '''
        struct: racl_policy_vec
        package: top_racl_pkg
        type: uni
        act: rcv
        width: 1
        inst_name: spi_host0
        index: -1
      }
      {
        name: racl_error
        desc: RACL error log information of this module.
        struct: racl_error_log
        package: top_racl_pkg
        type: uni
        act: req
        width: 1
        inst_name: spi_host0
        index: -1
      }
      {
        name: tl
        struct: tl
        package: tlul_pkg
        type: req_rsp
        act: rsp
        width: 1
        inst_name: spi_host0
        default: ""
        end_idx: -1
        top_type: one-to-one
        top_signame: spi_host0_tl
        index: -1
      }
      {
        name: passthrough
        struct: passthrough
        package: spi_device_pkg
        type: req_rsp
        act: rsp
        width: 1
        inst_name: spi_host1
        index: -1
      }
      {
        name: lsio_trigger
        desc:
          '''
          Self-clearing status trigger for the DMA.
          Set when RX or TX FIFOs are past their configured watermarks matching watermark interrupt behaviour.
          '''
        struct: logic
        type: uni
        act: req
        width: 1
        inst_name: spi_host1
        index: -1
      }
      {
        name: racl_policies
        desc:
          '''
          Incoming RACL policy vector from a racl_ctrl instance.
          The policy selection vector (parameter) selects the policy for each register.
          '''
        struct: racl_policy_vec
        package: top_racl_pkg
        type: uni
        act: rcv
        width: 1
        inst_name: spi_host1
        index: -1
      }
      {
        name: racl_error
        desc: RACL error log information of this module.
        struct: racl_error_log
        package: top_racl_pkg
        type: uni
        act: req
        width: 1
        inst_name: spi_host1
        index: -1
      }
      {
        name: tl
        struct: tl
        package: tlul_pkg
        type: req_rsp
        act: rsp
        width: 1
        inst_name: spi_host1
        default: ""
        end_idx: -1
        top_type: one-to-one
        top_signame: spi_host1_tl
        index: -1
      }
      {
        name: usb_rx_d
        desc: USB RX data from an external differential receiver, if available
        struct: logic
        type: uni
        act: rcv
        width: 1
        inst_name: usbdev
        default: ""
        package: ""
        external: true
        conn_type: false
        index: -1
        top_signame: usbdev_usb_rx_d
      }
      {
        name: usb_tx_d
        desc: USB transmit data value (not used if usb_tx_se0 is set)
        struct: logic
        type: uni
        act: req
        width: 1
        inst_name: usbdev
        default: ""
        package: ""
        external: true
        conn_type: false
        index: -1
        top_signame: usbdev_usb_tx_d
      }
      {
        name: usb_tx_se0
        desc: Force transmission of a USB single-ended zero (i.e. both D+ and D- are low) regardless of usb_tx_d
        struct: logic
        type: uni
        act: req
        width: 1
        inst_name: usbdev
        default: ""
        package: ""
        external: true
        conn_type: false
        index: -1
        top_signame: usbdev_usb_tx_se0
      }
      {
        name: usb_tx_use_d_se0
        desc: Use the usb_tx_d and usb_tx_se0 TX interface, instead of usb_dp_o and usb_dn_o
        struct: logic
        type: uni
        act: req
        width: 1
        inst_name: usbdev
        default: ""
        package: ""
        external: true
        conn_type: false
        index: -1
        top_signame: usbdev_usb_tx_use_d_se0
      }
      {
        name: usb_dp_pullup
        desc: USB D+ pullup control
        struct: logic
        type: uni
        act: req
        width: 1
        inst_name: usbdev
        default: ""
        package: ""
        end_idx: -1
        top_type: broadcast
        top_signame: usbdev_usb_dp_pullup
        index: -1
        external: true
        conn_type: false
      }
      {
        name: usb_dn_pullup
        desc: USB D- pullup control
        struct: logic
        type: uni
        act: req
        width: 1
        inst_name: usbdev
        default: ""
        package: ""
        end_idx: -1
        top_type: broadcast
        top_signame: usbdev_usb_dn_pullup
        index: -1
        external: true
        conn_type: false
      }
      {
        name: usb_rx_enable
        desc: USB differential receiver enable
        struct: logic
        type: uni
        act: req
        width: 1
        inst_name: usbdev
        default: ""
        package: ""
        external: true
        conn_type: false
        index: -1
        top_signame: usbdev_usb_rx_enable
      }
      {
        name: usb_ref_val
        desc: This indicates that USB timing reference signal 'usb_ref_pulse' is valid
        struct: logic
        type: uni
        act: req
        width: 1
        inst_name: usbdev
        default: ""
        package: ""
        end_idx: -1
        top_type: broadcast
        top_signame: usbdev_usb_ref_val
        index: -1
      }
      {
        name: usb_ref_pulse
        desc: USB timing reference signal. This signal pulses for a single 48MHz clock every 1ms USB frame
        struct: logic
        type: uni
        act: req
        width: 1
        inst_name: usbdev
        default: ""
        package: ""
        end_idx: -1
        top_type: broadcast
        top_signame: usbdev_usb_ref_pulse
        index: -1
      }
      {
        name: usb_aon_suspend_req
        desc: Request to activate the AON/Wake module and take control of the USB pullups
        struct: logic
        type: uni
        act: req
        width: 1
        inst_name: usbdev
        default: ""
        package: ""
        end_idx: -1
        top_type: broadcast
        top_signame: usbdev_usb_aon_suspend_req
        index: -1
        external: true
        conn_type: false
      }
      {
        name: usb_aon_wake_ack
        desc: Acknowledge a wake signal from the AON/Wake and relinquish control of the USB pullups
        struct: logic
        type: uni
        act: req
        width: 1
        inst_name: usbdev
        default: ""
        package: ""
        end_idx: -1
        top_type: broadcast
        top_signame: usbdev_usb_aon_wake_ack
        index: -1
        external: true
        conn_type: false
      }
      {
        name: usb_aon_bus_reset
        desc: Indicates that the reason for waking was that a USB Bus Reset occurred
        struct: logic
        type: uni
        act: rcv
        width: 1
        inst_name: usbdev
        default: ""
        package: ""
        end_idx: -1
        top_type: broadcast
        top_signame: usbdev_usb_aon_bus_reset
        index: -1
        external: true
        conn_type: false
      }
      {
        name: usb_aon_sense_lost
        desc: Indicates that the reason for waking was that the VBUS/SENSE signal became deasserted
        struct: logic
        type: uni
        act: rcv
        width: 1
        inst_name: usbdev
        default: ""
        package: ""
        end_idx: -1
        top_type: broadcast
        top_signame: usbdev_usb_aon_sense_lost
        index: -1
        external: true
        conn_type: false
      }
      {
        name: usb_aon_bus_not_idle
        desc: Indicates that the reason for waking was that the USB is in a non-idle state
        struct: logic
        type: uni
        act: rcv
        width: 1
        inst_name: usbdev
        default: ""
        package: ""
        end_idx: -1
        top_type: broadcast
        top_signame: usbdev_usb_aon_bus_not_idle
        index: -1
        external: true
        conn_type: false
      }
      {
        name: usb_aon_wake_detect_active
        desc: Indicates that the external AON/Wake module is active and controlling the USB pullups
        struct: logic
        type: uni
        act: rcv
        width: 1
        inst_name: usbdev
        default: ""
        package: ""
        domain: Main
        top_signame: pinmux_usbdev_wake_detect_active
        index: -1
        external: true
        conn_type: false
      }
      {
        name: ram_cfg
        struct: ram_1p_cfg
        package: prim_ram_1p_pkg
        type: req_rsp
        act: rsp
        width: 1
        inst_name: usbdev
        default: ""
        top_signame: usbdev_ram_cfg
        index: -1
      }
      {
        name: tl
        struct: tl
        package: tlul_pkg
        type: req_rsp
        act: rsp
        width: 1
        inst_name: usbdev
        default: ""
        end_idx: -1
        top_type: one-to-one
        top_signame: usbdev_tl
        index: -1
      }
      {
        name: pwr_ast
        struct: pwr_ast
        package: pwrmgr_pkg
        type: req_rsp
        act: req
        width: 1
        inst_name: pwrmgr
        default: ""
        end_idx: -1
        top_type: one-to-one
        top_signame: pwrmgr_pwr_ast
        index: -1
      }
      {
        name: pwr_rst
        struct: pwr_rst
        package: pwrmgr_pkg
        type: req_rsp
        act: req
        width: 1
        inst_name: pwrmgr
        default: ""
        end_idx: -1
        top_type: one-to-one
        top_signame: pwrmgr_pwr_rst
        index: -1
      }
      {
        name: pwr_clk
        struct: pwr_clk
        package: pwrmgr_pkg
        type: req_rsp
        act: req
        width: 1
        inst_name: pwrmgr
        default: ""
        end_idx: -1
        top_type: one-to-one
        top_signame: pwrmgr_pwr_clk
        index: -1
      }
      {
        name: pwr_otp
        struct: pwr_otp
        package: pwrmgr_pkg
        type: req_rsp
        act: req
        width: 1
        inst_name: pwrmgr
        default: ""
        end_idx: -1
        top_type: one-to-one
        top_signame: pwrmgr_pwr_otp
        index: -1
        external: true
        conn_type: false
      }
      {
        name: pwr_lc
        struct: pwr_lc
        package: lc_ctrl_pkg
        type: req_rsp
        act: req
        width: 1
        inst_name: pwrmgr
        default: ""
        end_idx: -1
        top_type: one-to-one
        top_signame: pwrmgr_pwr_lc
        index: -1
        external: true
        conn_type: false
      }
      {
        name: pwr_nvm
        struct: pwr_nvm
        package: pwrmgr_pkg
        type: uni
        act: rcv
        width: 1
        inst_name: pwrmgr
        default: ""
        end_idx: -1
        top_type: broadcast
        top_signame: pwrmgr_pwr_nvm
        index: -1
        external: true
        conn_type: false
      }
      {
        name: esc_rst_tx
        struct: esc_tx
        package: prim_esc_pkg
        type: uni
        act: rcv
        width: 1
        inst_name: pwrmgr
        default: ""
        domain: Aon
        top_signame: alert_handler_esc_tx
        index: -1
        external: true
        conn_type: false
      }
      {
        name: esc_rst_rx
        struct: esc_rx
        package: prim_esc_pkg
        type: uni
        act: req
        width: 1
        inst_name: pwrmgr
        default: ""
        domain: Aon
        top_signame: alert_handler_esc_rx
        index: -1
        external: true
        conn_type: false
      }
      {
        name: pwr_cpu
        struct: cpu_pwrmgr
        package: rv_core_ibex_pkg
        type: uni
        act: rcv
        width: 1
        inst_name: pwrmgr
        default: ""
        domain: Aon
        top_signame: rv_core_ibex_pwrmgr
        index: -1
        external: true
        conn_type: false
      }
      {
        name: wakeups
        struct: logic
        type: uni
        act: rcv
        width: 8
        inst_name: pwrmgr
        default: ""
        package: ""
        end_idx: -1
        top_type: one-to-N
        top_signame: pwrmgr_wakeups
        index: 1
        external: true
        conn_type: true
      }
      {
        name: rstreqs
        struct: logic
        type: uni
        act: rcv
        width: 2
        inst_name: pwrmgr
        default: ""
        package: ""
        end_idx: -1
        top_type: one-to-N
        top_signame: pwrmgr_rstreqs
        index: -1
      }
      {
        name: ndmreset_req
        struct: logic
        type: uni
        act: rcv
        width: 1
        inst_name: pwrmgr
        default: ""
        package: ""
        domain: Aon
        top_signame: rv_dm_ndmreset_req
        index: -1
        external: true
        conn_type: false
      }
      {
        name: strap
        struct: logic
        type: uni
        act: req
        width: 1
        inst_name: pwrmgr
        default: ""
        package: ""
        end_idx: -1
        top_type: broadcast
        top_signame: pwrmgr_strap
        index: -1
      }
      {
        name: low_power
        struct: logic
        type: uni
        act: req
        width: 1
        inst_name: pwrmgr
        default: ""
        package: ""
        end_idx: -1
        top_type: broadcast
        top_signame: pwrmgr_low_power
        index: -1
      }
      {
        name: rom_ctrl
        struct: pwrmgr_data
        package: rom_ctrl_pkg
        type: uni
        act: rcv
        width: 1
        default: rom_ctrl_pkg::PWRMGR_DATA_DEFAULT
        inst_name: pwrmgr
        domain: Aon
        top_signame: rom_ctrl_pwrmgr_data
        index: -1
        external: true
        conn_type: false
      }
      {
        name: fetch_en
        struct: lc_tx
        package: lc_ctrl_pkg
        type: uni
        act: req
        width: 1
        inst_name: pwrmgr
        default: ""
        end_idx: -1
        top_type: broadcast
        top_signame: pwrmgr_fetch_en
        index: -1
        external: true
        conn_type: false
      }
      {
        name: lc_dft_en
        struct: lc_tx
        package: lc_ctrl_pkg
        type: uni
        act: rcv
        width: 1
        inst_name: pwrmgr
        default: ""
        domain: Aon
        top_signame: lc_ctrl_lc_dft_en
        index: -1
        external: true
        conn_type: false
      }
      {
        name: lc_hw_debug_en
        struct: lc_tx
        package: lc_ctrl_pkg
        type: uni
        act: rcv
        width: 1
        inst_name: pwrmgr
        default: ""
        domain: Aon
        top_signame: lc_ctrl_lc_hw_debug_en
        index: -1
        external: true
        conn_type: false
      }
      {
        name: sw_rst_req
        struct: mubi4
        package: prim_mubi_pkg
        type: uni
        act: rcv
        width: 1
        inst_name: pwrmgr
        default: ""
        domain: Aon
        top_signame: rstmgr_sw_rst_req
        index: -1
      }
      {
        name: tl
        struct: tl
        package: tlul_pkg
        type: req_rsp
        act: rsp
        width: 1
        inst_name: pwrmgr
        default: ""
        end_idx: -1
        top_type: one-to-one
        top_signame: pwrmgr_tl
        index: -1
        external: true
        conn_type: false
      }
      {
        name: por_n
        desc:
          '''
          Root power on reset signals from ast.
          There is one root reset signal for each core power domain.
          '''
        struct: logic
        type: uni
        act: rcv
        width: 2
        inst_name: rstmgr
        default: ""
        package: ""
        end_idx: -1
        top_type: broadcast
        top_signame: rstmgr_por_n
        index: -1
      }
      {
        name: pwr
        desc:
          '''
          Reset request signals from power manager.
          Power manager can request for specific domains of the lc/sys reset tree to assert.
          '''
        struct: pwr_rst
        type: req_rsp
        act: rsp
        width: 1
        inst_name: rstmgr
        default: ""
        package: pwrmgr_pkg
        domain: Aon
        top_signame: pwrmgr_pwr_rst
        index: -1
      }
      {
        name: resets
        desc: Leaf resets fed to the system.
        struct: rstmgr_out
        package: rstmgr_pkg
        type: uni
        act: req
        width: 1
        inst_name: rstmgr
        default: ""
        domain: Aon
        top_signame: rstmgr_resets
        index: -1
      }
      {
        name: rst_en
        desc: Low-power-group outputs used by alert handler.
        struct: rstmgr_rst_en
        package: rstmgr_pkg
        type: uni
        act: req
        width: 1
        inst_name: rstmgr
        default: ""
        top_signame: rstmgr_rst_en
        index: -1
      }
      {
        name: alert_dump
        desc: Alert handler crash dump information.
        struct: alert_crashdump
        package: alert_handler_pkg
        type: uni
        act: rcv
        width: 1
        inst_name: rstmgr
        default: ""
        domain: Aon
        top_signame: alert_handler_crashdump
        index: -1
        external: true
        conn_type: false
      }
      {
        name: cpu_dump
        desc: Main processing element crash dump information.
        struct: cpu_crash_dump
        package: rv_core_ibex_pkg
        type: uni
        act: rcv
        width: 1
        inst_name: rstmgr
        default: ""
        domain: Aon
        top_signame: rv_core_ibex_crash_dump
        index: -1
        external: true
        conn_type: false
      }
      {
        name: sw_rst_req
        desc: Software requested system reset to pwrmgr.
        struct: mubi4
        package: prim_mubi_pkg
        type: uni
        act: req
        width: 1
        inst_name: rstmgr
        default: ""
        end_idx: -1
        top_type: broadcast
        top_signame: rstmgr_sw_rst_req
        index: -1
      }
      {
        name: tl
        struct: tl
        package: tlul_pkg
        type: req_rsp
        act: rsp
        width: 1
        inst_name: rstmgr
        default: ""
        end_idx: -1
        top_type: one-to-one
        top_signame: rstmgr_tl
        index: -1
        external: true
        conn_type: false
      }
      {
        name: clocks
        struct: clkmgr_out
        package: clkmgr_pkg
        type: uni
        act: req
        width: 1
        inst_name: clkmgr
        default: ""
        domain: Aon
        top_signame: clkmgr_clocks
        index: -1
      }
      {
        name: cg_en
        struct: clkmgr_cg_en
        package: clkmgr_pkg
        type: uni
        act: req
        width: 1
        inst_name: clkmgr
        default: ""
        top_signame: clkmgr_cg_en
        index: -1
      }
      {
        name: lc_hw_debug_en
        struct: lc_tx
        package: lc_ctrl_pkg
        type: uni
        act: rcv
        width: 1
        inst_name: clkmgr
        default: ""
        domain: Aon
        top_signame: lc_ctrl_lc_hw_debug_en
        index: -1
        external: true
        conn_type: false
      }
      {
        name: io_clk_byp_req
        struct: mubi4
        package: prim_mubi_pkg
        type: uni
        act: req
        width: 1
        inst_name: clkmgr
        default: ""
        end_idx: -1
        top_type: broadcast
        top_signame: clkmgr_io_clk_byp_req
        index: -1
        external: true
        conn_type: false
      }
      {
        name: io_clk_byp_ack
        struct: mubi4
        package: prim_mubi_pkg
        type: uni
        act: rcv
        width: 1
        inst_name: clkmgr
        default: ""
        end_idx: -1
        top_type: broadcast
        top_signame: clkmgr_io_clk_byp_ack
        index: -1
        external: true
        conn_type: false
      }
      {
        name: all_clk_byp_req
        struct: mubi4
        package: prim_mubi_pkg
        type: uni
        act: req
        width: 1
        inst_name: clkmgr
        default: ""
        end_idx: -1
        top_type: broadcast
        top_signame: clkmgr_all_clk_byp_req
        index: -1
        external: true
        conn_type: false
      }
      {
        name: all_clk_byp_ack
        struct: mubi4
        package: prim_mubi_pkg
        type: uni
        act: rcv
        width: 1
        inst_name: clkmgr
        default: ""
        end_idx: -1
        top_type: broadcast
        top_signame: clkmgr_all_clk_byp_ack
        index: -1
        external: true
        conn_type: false
      }
      {
        name: hi_speed_sel
        struct: mubi4
        package: prim_mubi_pkg
        type: uni
        act: req
        width: 1
        inst_name: clkmgr
        default: ""
        end_idx: -1
        top_type: broadcast
        top_signame: clkmgr_hi_speed_sel
        index: -1
        external: true
        conn_type: false
      }
      {
        name: div_step_down_req
        struct: mubi4
        package: prim_mubi_pkg
        type: uni
        act: rcv
        width: 1
        inst_name: clkmgr
        default: ""
        end_idx: -1
        top_type: broadcast
        top_signame: clkmgr_div_step_down_req
        index: -1
        external: true
        conn_type: false
      }
      {
        name: lc_clk_byp_req
        struct: lc_tx
        package: lc_ctrl_pkg
        type: uni
        act: rcv
        width: 1
        inst_name: clkmgr
        default: ""
        domain: Aon
        top_signame: lc_ctrl_lc_clk_byp_req
        index: -1
        external: true
        conn_type: false
      }
      {
        name: lc_clk_byp_ack
        struct: lc_tx
        package: lc_ctrl_pkg
        type: uni
        act: req
        width: 1
        inst_name: clkmgr
        default: ""
        domain: Aon
        top_signame: lc_ctrl_lc_clk_byp_ack
        index: -1
        external: true
        conn_type: false
      }
      {
        name: jitter_en
        struct: mubi4
        package: prim_mubi_pkg
        type: uni
        act: req
        width: 1
        inst_name: clkmgr
        default: ""
        domain: Aon
        top_signame: ast_clk_src_sys_jen
        index: -1
        external: true
        conn_type: false
      }
      {
        name: pwr
        struct: pwr_clk
        type: req_rsp
        act: rsp
        width: 1
        inst_name: clkmgr
        default: ""
        package: pwrmgr_pkg
        domain: Aon
        top_signame: pwrmgr_pwr_clk
        index: -1
      }
      {
        name: idle
        struct: mubi4
        package: prim_mubi_pkg
        type: uni
        act: rcv
        width: 4
        inst_name: clkmgr
        default: ""
        end_idx: -1
        top_type: one-to-N
        top_signame: clkmgr_idle
        index: -1
        external: true
        conn_type: false
      }
      {
        name: calib_rdy
        desc: Indicates clocks are calibrated and frequencies accurate
        struct: mubi4
        package: prim_mubi_pkg
        type: uni
        act: rcv
        width: 1
        default: prim_mubi_pkg::MuBi4True
        inst_name: clkmgr
        domain: Aon
        top_signame: ast_init_done
        index: -1
        external: true
        conn_type: false
      }
      {
        name: tl
        struct: tl
        package: tlul_pkg
        type: req_rsp
        act: rsp
        width: 1
        inst_name: clkmgr
        default: ""
        end_idx: -1
        top_type: one-to-one
        top_signame: clkmgr_tl
        index: -1
        external: true
        conn_type: false
      }
      {
        name: wkup_req
        struct: logic
        type: uni
        act: req
        width: 1
        inst_name: sysrst_ctrl
        default: ""
        package: ""
        domain: Aon
        top_signame: pwrmgr_wakeups
        index: 2
      }
      {
        name: rst_req
        struct: logic
        type: uni
        act: req
        width: 1
        inst_name: sysrst_ctrl
        default: ""
        package: ""
        domain: Aon
        top_signame: pwrmgr_rstreqs
        index: 0
      }
      {
        name: tl
        struct: tl
        package: tlul_pkg
        type: req_rsp
        act: rsp
        width: 1
        inst_name: sysrst_ctrl
        default: ""
        end_idx: -1
        top_type: one-to-one
        top_signame: sysrst_ctrl_tl
        index: -1
        external: true
        conn_type: false
      }
      {
        name: adc
        struct: adc_ast
        package: ast_pkg
        type: req_rsp
        act: req
        width: 1
        inst_name: adc_ctrl
        default: ""
        domain: Aon
        top_signame: ast_adc
        index: -1
      }
      {
        name: wkup_req
        struct: logic
        type: uni
        act: req
        width: 1
        inst_name: adc_ctrl
        default: ""
        package: ""
        domain: Aon
        top_signame: pwrmgr_wakeups
        index: 3
      }
      {
        name: tl
        struct: tl
        package: tlul_pkg
        type: req_rsp
        act: rsp
        width: 1
        inst_name: adc_ctrl
        default: ""
        end_idx: -1
        top_type: one-to-one
        top_signame: adc_ctrl_tl
        index: -1
        external: true
        conn_type: false
      }
      {
        name: lc_hw_debug_clr
        desc: Debug clear signal coming from life cycle controller, used for HW strap qualification.
        struct: lc_tx
        package: lc_ctrl_pkg
        type: uni
        act: rcv
        width: 1
        default: lc_ctrl_pkg::Off
        inst_name: pinmux
        domain: Aon
        top_signame: lc_ctrl_lc_hw_debug_clr
        index: -1
        external: true
        conn_type: false
      }
      {
        name: lc_hw_debug_en
        desc: Debug enable qualifier coming from life cycle controller, used for HW strap qualification.
        struct: lc_tx
        package: lc_ctrl_pkg
        type: uni
        act: rcv
        width: 1
        default: lc_ctrl_pkg::Off
        inst_name: pinmux
        domain: Aon
        top_signame: lc_ctrl_lc_hw_debug_en
        index: -1
        external: true
        conn_type: false
      }
      {
        name: lc_dft_en
        desc: Test enable qualifier coming from life cycle controller, used for HW strap qualification.
        struct: lc_tx
        package: lc_ctrl_pkg
        type: uni
        act: rcv
        width: 1
        default: lc_ctrl_pkg::Off
        inst_name: pinmux
        domain: Aon
        top_signame: lc_ctrl_lc_dft_en
        index: -1
        external: true
        conn_type: false
      }
      {
        name: lc_nvm_debug_en
        desc:
          '''
          NVM debug enable coming from life cycle controller.
          The RRAM TAP can only be selected while this signal is On.
          '''
        struct: lc_tx
        package: lc_ctrl_pkg
        type: uni
        act: rcv
        width: 1
        default: lc_ctrl_pkg::Off
        inst_name: pinmux
        domain: Aon
        top_signame: lc_ctrl_lc_nvm_debug_en
        index: -1
        external: true
        conn_type: false
      }
      {
        name: lc_escalate_en
        desc:
          '''
          Escalation enable signal coming from life cycle controller, used for invalidating
          the latched lc_hw_debug_en state inside the strap sampling logic.
          '''
        struct: lc_tx
        package: lc_ctrl_pkg
        type: uni
        act: rcv
        width: 1
        default: lc_ctrl_pkg::Off
        inst_name: pinmux
        domain: Aon
        top_signame: lc_ctrl_lc_escalate_en
        index: -1
        external: true
        conn_type: false
      }
      {
        name: lc_check_byp_en
        desc:
          '''
          Check bypass enable signal coming from life cycle controller, used for invalidating
          the latched lc_hw_debug_en state inside the strap sampling logic. This signal is asserted
          whenever the life cycle controller performs a life cycle transition. Its main use is
          to skip any background checks inside the life cycle partition of the OTP controller while
          a life cycle transition is in progress.
          '''
        struct: lc_tx
        package: lc_ctrl_pkg
        type: uni
        act: rcv
        width: 1
        default: lc_ctrl_pkg::Off
        inst_name: pinmux
        domain: Aon
        top_signame: lc_ctrl_lc_check_byp_en
        index: -1
        external: true
        conn_type: false
      }
      {
        name: pinmux_hw_debug_en
        desc:
          '''
          This is the latched version of lc_hw_debug_en_i. We use it exclusively to gate the JTAG
          signals and TAP side of the RV_DM so that RV_DM can remain live during an NDM reset cycle.
          '''
        struct: lc_tx
        package: lc_ctrl_pkg
        type: uni
        act: req
        width: 1
        default: lc_ctrl_pkg::Off
        inst_name: pinmux
        end_idx: -1
        top_type: broadcast
        top_signame: pinmux_pinmux_hw_debug_en
        index: -1
        external: true
        conn_type: false
      }
      {
        name: lc_jtag
        desc: Qualified JTAG signals for life cycle controller TAP.
        struct: jtag
        package: jtag_pkg
        type: req_rsp
        act: req
        width: 1
        inst_name: pinmux
        default: ""
        end_idx: -1
        top_type: one-to-one
        top_signame: pinmux_lc_jtag
        index: -1
        external: true
        conn_type: false
      }
      {
        name: rv_jtag
        desc: Qualified JTAG signals for RISC-V processor TAP.
        struct: jtag
        package: jtag_pkg
        type: req_rsp
        act: req
        width: 1
        inst_name: pinmux
        default: ""
        end_idx: -1
        top_type: one-to-one
        top_signame: pinmux_rv_jtag
        index: -1
        external: true
        conn_type: false
      }
      {
        name: dft_jtag
        desc: Qualified JTAG signals for DFT TAP.
        struct: jtag
        package: jtag_pkg
        type: req_rsp
        act: req
        width: 1
        inst_name: pinmux
        default: ""
        top_signame: pinmux_dft_jtag
        index: -1
      }
      {
        name: rram_jtag
        desc: Qualified JTAG signals for the RRAM TAP.
        struct: jtag
        package: jtag_pkg
        type: req_rsp
        act: req
        width: 1
        inst_name: pinmux
        default: ""
        end_idx: -1
        top_type: one-to-one
        top_signame: pinmux_rram_jtag
        index: -1
        external: true
        conn_type: false
      }
      {
        name: dft_strap_test
        desc: Sampled DFT strap values, going to the DFT TAP.
        struct: dft_strap_test_req
        package: pinmux_pkg
        type: uni
        act: req
        width: 1
        default: "'0"
        inst_name: pinmux
        end_idx: -1
        top_type: broadcast
        top_signame: pinmux_dft_strap_test
        index: -1
      }
      {
        name: dft_hold_tap_sel
        desc: TAP selection hold indication, asserted by the DFT TAP during boundary scan.
        struct: logic
        type: uni
        act: rcv
        width: 1
        default: "'0"
        inst_name: pinmux
        package: ""
        external: true
        conn_type: false
        index: -1
        top_signame: dft_hold_tap_sel
      }
      {
        name: sleep_en
        desc: Level signal that is asserted when the power manager enters sleep.
        struct: logic
        type: uni
        act: rcv
        width: 1
        default: 1'b0
        inst_name: pinmux
        package: ""
        domain: Aon
        top_signame: pwrmgr_low_power
        index: -1
      }
      {
        name: strap_en
        desc: This signal is pulsed high by the power manager after reset in order to sample the HW straps.
        struct: logic
        type: uni
        act: rcv
        width: 1
        default: 1'b0
        inst_name: pinmux
        package: ""
        domain: Aon
        top_signame: pwrmgr_strap
        index: -1
      }
      {
        name: strap_en_override
        desc:
          '''
          This signal transitions from 0 -> 1 by the lc_ctrl manager after volatile RAW_UNLOCK in order to re-sample the HW straps.
          The signal must stay at 1 until reset.
          Note that this is only used in test chips when SecVolatileRawUnlockEn = 1.
          Otherwise this signal is unused.
          '''
        struct: logic
        type: uni
        act: rcv
        width: 1
        default: 1'b0
        inst_name: pinmux
        package: ""
        domain: Aon
        top_signame: lc_ctrl_strap_en_override
        index: -1
        external: true
        conn_type: false
      }
      {
        name: pin_wkup_req
        desc: Wakeup request from wakeup detectors, to the power manager, running on the AON clock.
        struct: logic
        type: uni
        act: req
        width: 1
        default: 1'b0
        inst_name: pinmux
        package: ""
        domain: Aon
        top_signame: pwrmgr_wakeups
        index: 4
      }
      {
        name: usbdev_dppullup_en
        desc: Pullup enable signal coming from the USB IP.
        struct: logic
        type: uni
        act: rcv
        width: 1
        inst_name: pinmux
        default: ""
        package: ""
        domain: Aon
        top_signame: usbdev_usb_dp_pullup
        index: -1
        external: true
        conn_type: false
      }
      {
        name: usbdev_dnpullup_en
        desc: Pullup enable signal coming from the USB IP.
        struct: logic
        type: uni
        act: rcv
        width: 1
        inst_name: pinmux
        default: ""
        package: ""
        domain: Aon
        top_signame: usbdev_usb_dn_pullup
        index: -1
        external: true
        conn_type: false
      }
      {
        name: usb_dppullup_en
        desc: " Pullup enable signal going to USB PHY, needs to be maintained in low-power mode."
        struct: logic
        type: uni
        act: req
        width: 1
        default: 1'b0
        inst_name: pinmux
        package: ""
        external: true
        conn_type: false
        index: -1
        top_signame: usb_dp_pullup_en
      }
      {
        name: usb_dnpullup_en
        desc: Pullup enable signal going to USB PHY, needs to be maintained in low-power mode.
        struct: logic
        type: uni
        act: req
        width: 1
        default: 1'b0
        inst_name: pinmux
        package: ""
        external: true
        conn_type: false
        index: -1
        top_signame: usb_dn_pullup_en
      }
      {
        name: usb_wkup_req
        desc: Wakeup request from USB wakeup detector, going to the power manager, running on the AON clock.
        struct: logic
        type: uni
        act: req
        width: 1
        default: 1'b0
        inst_name: pinmux
        package: ""
        domain: Aon
        top_signame: pwrmgr_wakeups
        index: 5
      }
      {
        name: usbdev_suspend_req
        desc: Indicates whether USB is in suspended state, coming from the USB device.
        struct: logic
        type: uni
        act: rcv
        width: 1
        inst_name: pinmux
        default: ""
        package: ""
        domain: Aon
        top_signame: usbdev_usb_aon_suspend_req
        index: -1
        external: true
        conn_type: false
      }
      {
        name: usbdev_wake_ack
        desc: Acknowledges the USB wakeup request, coming from the USB device.
        struct: logic
        type: uni
        act: rcv
        width: 1
        inst_name: pinmux
        default: ""
        package: ""
        domain: Aon
        top_signame: usbdev_usb_aon_wake_ack
        index: -1
        external: true
        conn_type: false
      }
      {
        name: usbdev_bus_not_idle
        desc: Event signal that indicates that the USB was not idle while monitoring.
        struct: logic
        type: uni
        act: req
        width: 1
        default: 1'b0
        inst_name: pinmux
        package: ""
        domain: Aon
        top_signame: usbdev_usb_aon_bus_not_idle
        index: -1
        external: true
        conn_type: false
      }
      {
        name: usbdev_bus_reset
        desc: Event signal that indicates that the USB issued a Bus Reset while monitoring.
        struct: logic
        type: uni
        act: req
        width: 1
        default: 1'b0
        inst_name: pinmux
        package: ""
        domain: Aon
        top_signame: usbdev_usb_aon_bus_reset
        index: -1
        external: true
        conn_type: false
      }
      {
        name: usbdev_sense_lost
        desc: Event signal that indicates that USB SENSE signal was lost while monitoring.
        struct: logic
        type: uni
        act: req
        width: 1
        default: 1'b0
        inst_name: pinmux
        package: ""
        domain: Aon
        top_signame: usbdev_usb_aon_sense_lost
        index: -1
        external: true
        conn_type: false
      }
      {
        name: usbdev_wake_detect_active
        desc: State debug information.
        struct: logic
        type: uni
        act: req
        width: 1
        default: 1'b0
        inst_name: pinmux
        package: ""
        end_idx: -1
        top_type: broadcast
        top_signame: pinmux_usbdev_wake_detect_active
        index: -1
        external: true
        conn_type: false
      }
      {
        name: tl
        struct: tl
        package: tlul_pkg
        type: req_rsp
        act: rsp
        width: 1
        inst_name: pinmux
        default: ""
        end_idx: -1
        top_type: one-to-one
        top_signame: pinmux_tl
        index: -1
        external: true
        conn_type: false
      }
      {
        name: nmi_wdog_timer_bark
        struct: logic
        type: uni
        act: req
        width: 1
        default: 1'b0
        inst_name: aon_timer
        package: ""
        end_idx: -1
        top_type: broadcast
        top_signame: aon_timer_nmi_wdog_timer_bark
        index: -1
        external: true
        conn_type: false
      }
      {
        name: wkup_req
        struct: logic
        type: uni
        act: req
        width: 1
        default: 1'b0
        inst_name: aon_timer
        package: ""
        domain: Aon
        top_signame: pwrmgr_wakeups
        index: 6
      }
      {
        name: aon_timer_rst_req
        struct: logic
        type: uni
        act: req
        width: 1
        default: 1'b0
        inst_name: aon_timer
        package: ""
        domain: Aon
        top_signame: pwrmgr_rstreqs
        index: 1
      }
      {
        name: lc_escalate_en
        struct: lc_tx
        package: lc_ctrl_pkg
        type: uni
        act: rcv
        width: 1
        default: lc_ctrl_pkg::Off
        inst_name: aon_timer
        domain: Aon
        top_signame: lc_ctrl_lc_escalate_en
        index: -1
        external: true
        conn_type: false
      }
      {
        name: sleep_mode
        struct: logic
        type: uni
        act: rcv
        width: 1
        inst_name: aon_timer
        default: ""
        package: ""
        domain: Aon
        top_signame: pwrmgr_low_power
        index: -1
      }
      {
        name: racl_policies
        desc:
          '''
          Incoming RACL policy vector from a racl_ctrl instance.
          The policy selection vector (parameter) selects the policy for each register.
          '''
        struct: racl_policy_vec
        package: top_racl_pkg
        type: uni
        act: rcv
        width: 1
        inst_name: aon_timer
        index: -1
      }
      {
        name: racl_error
        desc: RACL error log information of this module.
        struct: racl_error_log
        package: top_racl_pkg
        type: uni
        act: req
        width: 1
        inst_name: aon_timer
        index: -1
      }
      {
        name: tl
        struct: tl
        package: tlul_pkg
        type: req_rsp
        act: rsp
        width: 1
        inst_name: aon_timer
        default: ""
        end_idx: -1
        top_type: one-to-one
        top_signame: aon_timer_tl
        index: -1
        external: true
        conn_type: false
      }
      {
        name: rng_b
        desc: RNG bit stream(s) generated
        struct: logic
        type: uni
        act: req
        width:
        {
          name: EntropyStreams
          desc: Number of RNG bit streams
          param_type: int unsigned
          unpacked_dimensions: null
          default: 4
          local: true
          expose: true
          name_top: AstEntropyStreams
        }
        inst_name: ast
        default: ""
        package: ""
        end_idx: -1
        top_type: broadcast
        top_signame: ast_rng_b
        index: -1
      }
      {
        name: init_done
        desc: AST (registers) init done
        struct: mubi4
        package: prim_mubi_pkg
        type: uni
        act: req
        width: 1
        inst_name: ast
        default: ""
        end_idx: -1
        top_type: broadcast
        top_signame: ast_init_done
        index: -1
        external: true
        conn_type: false
      }
      {
        name: rng_en
        desc: RNG enable
        struct: logic
        type: uni
        act: rcv
        width: 1
        inst_name: ast
        default: ""
        package: ""
        domain: Main
        top_signame: entropy_src_entropy_src_rng_enable
        index: -1
      }
      {
        name: rng_fips
        desc: RNG FIPS
        struct: logic
        type: uni
        act: rcv
        width: 1
        inst_name: ast
        default: ""
        package: ""
        domain: Main
        top_signame: entropy_src_rng_fips
        index: -1
      }
      {
        name: rng_val
        desc: RNG valid
        struct: logic
        type: uni
        act: req
        width: 1
        inst_name: ast
        default: ""
        package: ""
        end_idx: -1
        top_type: broadcast
        top_signame: ast_rng_val
        index: -1
      }
      {
        name: edn
        desc: Entropy distribution request/response
        struct: edn
        package: edn_pkg
        type: req_rsp
        act: req
        width: 1
        inst_name: ast
        default: ""
        domain: Main
        top_signame: edn0_edn
        index: 2
      }
      {
        name: clk_src_sys_jen
        desc: SYS source clock jitter enable
        struct: mubi4
        package: prim_mubi_pkg
        type: uni
        act: rcv
        width: 1
        inst_name: ast
        default: ""
        end_idx: -1
        top_type: broadcast
        top_signame: ast_clk_src_sys_jen
        index: -1
        external: true
        conn_type: false
      }
      {
        name: clk_src_sys
        desc: SYS source clock
        struct: logic
        type: uni
        act: req
        width: 1
        inst_name: ast
        index: -1
        package: ""
        default: ""
        top_signame: ast_clk_src_sys
        conn_type: false
        external: true
      }
      {
        name: clk_src_io
        desc: IO source clock
        struct: logic
        type: uni
        act: req
        width: 1
        inst_name: ast
        index: -1
        package: ""
        default: ""
        top_signame: ast_clk_src_io
        conn_type: false
        external: true
      }
      {
        name: clk_src_io_48m
        desc: IO source clock is 48MHz
        struct: mubi4
        package: prim_mubi_pkg
        type: uni
        act: req
        width: 1
        inst_name: ast
        default: ""
        domain: Main
        top_signame: clkmgr_div_step_down_req
        index: -1
        external: true
        conn_type: false
      }
      {
        name: clk_src_usb
        desc: USB source clock
        struct: logic
        type: uni
        act: req
        width: 1
        inst_name: ast
        index: -1
        package: ""
        default: ""
        top_signame: ast_clk_src_usb
        conn_type: false
        external: true
      }
      {
        name: io_clk_byp_ack
        desc: Switch IO clock to external clock ack
        struct: mubi4
        package: prim_mubi_pkg
        type: uni
        act: req
        width: 1
        inst_name: ast
        default: ""
        domain: Main
        top_signame: clkmgr_io_clk_byp_ack
        index: -1
        external: true
        conn_type: false
      }
      {
        name: all_clk_byp_ack
        desc: Switch all clocks to external clocks ack
        struct: mubi4
        package: prim_mubi_pkg
        type: uni
        act: req
        width: 1
        inst_name: ast
        default: ""
        domain: Main
        top_signame: clkmgr_all_clk_byp_ack
        index: -1
        external: true
        conn_type: false
      }
      {
        name: usb_io_pu_cal
        desc: USB IO pull-up calibration setting
        struct: logic
        type: uni
        act: req
        width:
        {
          name: UsbCalibWidth
          desc: Width of the USB IO pull-up calibration setting
          param_type: int unsigned
          unpacked_dimensions: null
          partition: secondary
          default: 20
          local: false
          expose: true
          name_top: AstUsbCalibWidth
        }
        partition: secondary
        inst_name: ast
        default: ""
        package: ""
        external: true
        conn_type: false
        index: -1
        top_signame: usb_io_pu_cal
      }
      {
        name: adc
        desc: ADC interface
        struct: adc_ast
        package: ast_pkg
        type: req_rsp
        act: rsp
        width: 1
        partition: secondary
        inst_name: ast
        default: ""
        end_idx: -1
        top_type: one-to-one
        top_signame: ast_adc
        index: -1
      }
      {
        name: adc_a0_a
        desc: ADC A0 Analog Input
        struct: awire
        package: ast_pkg
        type: uni
        act: rcv
        width: 1
        partition: secondary
        inst_name: ast
        default: ""
        external: true
        conn_type: false
        index: -1
        top_signame: ast_adc_a0_a
      }
      {
        name: adc_a1_a
        desc: ADC A1 Analog Input
        struct: awire
        package: ast_pkg
        type: uni
        act: rcv
        width: 1
        partition: secondary
        inst_name: ast
        default: ""
        external: true
        conn_type: false
        index: -1
        top_signame: ast_adc_a1_a
      }
      {
        name: ast2pad_t0_a
        desc: AST_2_PAD Analog T0 Output Signal
        struct: awire
        package: ast_pkg
        type: uni
        act: req
        width: 1
        partition: secondary
        inst_name: ast
        default: ""
        external: true
        conn_type: false
        index: -1
        top_signame: ast2pad_t0_a
      }
      {
        name: ast2pad_t1_a
        desc: AST_2_PAD Analog T1 Output Signal
        struct: awire
        package: ast_pkg
        type: uni
        act: req
        width: 1
        partition: secondary
        inst_name: ast
        default: ""
        external: true
        conn_type: false
        index: -1
        top_signame: ast2pad_t1_a
      }
      {
        name: padmux2ast
        desc: IO-to-DFT input signals
        struct: logic
        type: uni
        act: rcv
        width:
        {
          name: Pad2AstInWidth
          desc: Width of the DFT pad-to-AST input signal bus
          param_type: int unsigned
          unpacked_dimensions: null
          partition: secondary
          default: 8
          local: false
          expose: true
          name_top: AstPad2AstInWidth
        }
        partition: secondary
        inst_name: ast
        default: ""
        package: ""
        external: true
        conn_type: false
        index: -1
        top_signame: padmux2ast
      }
      {
        name: ast2padmux
        desc: DFT-to-IO output signals
        struct: logic
        type: uni
        act: req
        width:
        {
          name: Ast2PadOutWidth
          desc: Width of the DFT AST-to-pad output signal bus
          param_type: int unsigned
          unpacked_dimensions: null
          partition: secondary
          default: 9
          local: true
          expose: true
          name_top: AstAst2PadOutWidth
        }
        partition: secondary
        inst_name: ast
        default: ""
        package: ""
        end_idx: -1
        top_type: broadcast
        top_signame: ast_ast2padmux
        index: -1
      }
      {
        name: por_n
        desc: External power ON reset based on VCC
        struct: logic
        type: uni
        act: rcv
        width: 1
        partition: secondary
        inst_name: ast
        default: ""
        package: ""
        external: true
        conn_type: false
        index: -1
        top_signame: manual_in_por_n
      }
      {
        name: pora_n
        desc: External power ON reset based on VIOA
        struct: logic
        type: uni
        act: rcv
        width: 1
        partition: secondary
        inst_name: ast
        default: ""
        package: ""
        external: true
        conn_type: false
        index: -1
        top_signame: manual_in_pora_n
      }
      {
        name: sns_clks
        desc: Sensed clocks
        struct: clkmgr_out
        package: clkmgr_pkg
        type: uni
        act: rcv
        width: 1
        partition: secondary
        inst_name: ast
        default: ""
        end_idx: -1
        top_type: broadcast
        top_signame: ast_sns_clks
        index: -1
      }
      {
        name: sns_rsts
        desc: Sensed resets
        struct: rstmgr_out
        package: rstmgr_pkg
        type: uni
        act: rcv
        width: 1
        partition: secondary
        inst_name: ast
        default: ""
        end_idx: -1
        top_type: broadcast
        top_signame: ast_sns_rsts
        index: -1
      }
      {
        name: vx_supp
        desc: Supply voltage tests for OS FPGA
        struct: ast_vx_supp
        package: ast_pkg
        type: uni
        act: rcv
        width: 1
        partition: secondary
        inst_name: ast
        default: ""
        external: true
        conn_type: false
        index: -1
        top_signame: ast_vx_supp
      }
      {
        name: ast_pwst_h
        desc: AON, MAIN, IO-0 rail, IO-1 rail power OK @3.3V
        struct: ast_pwst
        package: ast_pkg
        type: uni
        act: req
        width: 1
        partition: secondary
        inst_name: ast
        default: ""
        external: true
        conn_type: false
        index: -1
        top_signame: ast_pwst_h
      }
      {
        name: rstmgr_por_n
        desc: Per-power-domain power-on-reset for rstmgr
        struct: logic
        type: uni
        act: req
        width: 2
        partition: secondary
        inst_name: ast
        default: ""
        package: ""
        domain: Aon
        top_signame: rstmgr_por_n
        index: -1
      }
      {
        name: io_pwr_st
        desc: IO power state
        struct: ast_status
        package: ast_pkg
        type: uni
        act: req
        width: 1
        partition: secondary
        inst_name: ast
        default: ""
        end_idx: -1
        top_type: broadcast
        top_signame: ast_io_pwr_st
        index: -1
      }
      {
        name: pwrmgr
        desc: Interface to pwrmgr
        struct: pwr_ast
        package: pwrmgr_pkg
        type: req_rsp
        act: rsp
        width: 1
        partition: secondary
        inst_name: ast
        default: ""
        domain: Aon
        top_signame: pwrmgr_pwr_ast
        index: -1
      }
      {
        name: flash_power_down_h
        desc: Flash power down
        struct: logic
        type: uni
        act: req
        width: 1
        partition: secondary
        inst_name: ast
        index: -1
      }
      {
        name: flash_power_ready_h
        desc: Flash power ready
        struct: logic
        type: uni
        act: req
        width: 1
        partition: secondary
        inst_name: ast
        index: -1
      }
      {
        name: otp_power_seq
        desc: OTP power sequencing, in (VDD)
        struct: logic
        type: uni
        act: rcv
        width: 2
        partition: secondary
        inst_name: ast
        index: -1
      }
      {
        name: otp_power_seq_h
        desc: OTP power sequencing masked by PDM, out (VCC)
        struct: logic
        type: uni
        act: req
        width: 2
        partition: secondary
        inst_name: ast
        index: -1
      }
      {
        name: clk_src_aon
        desc: AON source clock
        struct: logic
        type: uni
        act: req
        width: 1
        partition: secondary
        inst_name: ast
        default: ""
        package: ""
        top_signame: ast_clk_src_aon
        index: -1
      }
      {
        name: usb_ref_pulse
        desc: USB reference pulse
        struct: logic
        type: uni
        act: rcv
        width: 1
        inst_name: ast
        default: ""
        package: ""
        domain: Main
        top_signame: usbdev_usb_ref_pulse
        index: -1
      }
      {
        name: usb_ref_val
        desc: USB reference valid
        struct: logic
        type: uni
        act: rcv
        width: 1
        inst_name: ast
        default: ""
        package: ""
        domain: Main
        top_signame: usbdev_usb_ref_val
        index: -1
      }
      {
        name: alert
        desc: Analog alert events to sensor_ctrl
        struct: ast_alert
        package: ast_pkg
        type: req_rsp
        act: req
        width: 1
        partition: secondary
        inst_name: ast
        default: ""
        domain: Aon
        top_signame: sensor_ctrl_ast_alert
        index: -1
      }
      {
        name: dft_strap_test
        desc: DFT straps
        struct: dft_strap_test_req
        package: pinmux_pkg
        type: uni
        act: rcv
        width: 1
        partition: secondary
        inst_name: ast
        default: ""
        domain: Aon
        top_signame: pinmux_dft_strap_test
        index: -1
      }
      {
        name: lc_dft_en
        desc: DFT enable (secure bus)
        struct: lc_tx
        package: lc_ctrl_pkg
        type: uni
        act: rcv
        width: 1
        partition: secondary
        inst_name: ast
        default: ""
        domain: Aon
        top_signame: lc_ctrl_lc_dft_en
        index: -1
        external: true
        conn_type: false
      }
      {
        name: obs
        desc: Observe bus
        struct: ast_obs_bus
        package: ast_pkg
        type: uni
        act: rcv
        width: 1
        partition: secondary
        inst_name: ast
        default: ""
        external: true
        conn_type: false
        index: -1
        top_signame: ast_obs
      }
      {
        name: obs_ctrl
        desc: Observe control
        struct: ast_obs_ctrl
        package: ast_pkg
        type: uni
        act: req
        width: 1
        partition: secondary
        inst_name: ast
        default: ""
        end_idx: -1
        top_type: broadcast
        top_signame: ast_obs_ctrl
        index: -1
        external: true
        conn_type: false
      }
      {
        name: flash_bist_en
        desc: Flash BIST (TAP) enable
        struct: mubi4
        package: prim_mubi_pkg
        type: uni
        act: req
        width: 1
        partition: secondary
        inst_name: ast
        index: -1
      }
      {
        name: dft_scan_md
        desc: Scan mode output
        struct: mubi4
        package: prim_mubi_pkg
        type: uni
        act: req
        width: 1
        partition: secondary
        inst_name: ast
        default: ""
        external: true
        conn_type: false
        index: -1
        top_signame: scanmode
      }
      {
        name: scan_shift_en
        desc: Scan shift enable output
        struct: logic
        type: uni
        act: req
        width: 1
        partition: secondary
        inst_name: ast
        default: ""
        package: ""
        external: true
        conn_type: false
        index: -1
        top_signame: scan_en
      }
      {
        name: scan_reset_n
        desc: Scan reset output
        struct: logic
        type: uni
        act: req
        width: 1
        partition: secondary
        inst_name: ast
        default: ""
        package: ""
        external: true
        conn_type: false
        index: -1
        top_signame: scan_rst_n
      }
      {
        name: mem_cfg
        desc: Memory configuration
        struct: ast_mem_cfg_primary
        package: ast_pkg
        type: req_rsp
        act: req
        width: 1
        inst_name: ast
        default: ""
        top_signame: ast_mem_cfg
        index: -1
      }
      {
        name: mem_cfg
        desc: Memory configuration
        struct: ast_mem_cfg_secondary
        package: ast_pkg
        type: req_rsp
        act: req
        width: 1
        partition: secondary
        inst_name: ast
        default: ""
        top_signame: ast_mem_cfg
        index: -1
      }
      {
        name: clk_osc_byp
        desc: Clocks' oscillator bypass for OS FPGA/Verilator (AST_BYPASS_CLK only)
        struct: clks_osc_byp
        package: ast_pkg
        type: uni
        act: rcv
        width: 1
        inst_name: ast
        default: ""
        top_signame: ast_clk_osc_byp
        index: -1
        external: true
        conn_type: true
      }
      {
        name: ext_freq_is_96m
        desc: External clock frequency is 96MHz
        struct: mubi4
        package: prim_mubi_pkg
        type: uni
        act: rcv
        width: 1
        inst_name: ast
        default: ""
        domain: Main
        top_signame: clkmgr_hi_speed_sel
        index: -1
        external: true
        conn_type: false
      }
      {
        name: all_clk_byp_req
        desc: All clocks bypass request
        struct: mubi4
        package: prim_mubi_pkg
        type: uni
        act: rcv
        width: 1
        inst_name: ast
        default: ""
        domain: Main
        top_signame: clkmgr_all_clk_byp_req
        index: -1
        external: true
        conn_type: false
      }
      {
        name: io_clk_byp_req
        desc: IO clock bypass request (for OTP bootstrap)
        struct: mubi4
        package: prim_mubi_pkg
        type: uni
        act: rcv
        width: 1
        inst_name: ast
        default: ""
        domain: Main
        top_signame: clkmgr_io_clk_byp_req
        index: -1
        external: true
        conn_type: false
      }
      {
        name: intraip_s2p
        desc: Secondary-to-Primary partition communication
        struct: s2p
        package: ast_intraip_pkg
        type: uni
        act: rcv
        width: 1
        inst_name: ast
        default: ""
        domain: Main
        top_signame: ast_intraip_s2p
        index: -1
        external: true
        conn_type: false
      }
      {
        name: intraip_p2s
        desc: Primary-to-Secondary partition communication
        struct: p2s
        package: ast_intraip_pkg
        type: uni
        act: req
        width: 1
        inst_name: ast
        default: ""
        end_idx: -1
        top_type: broadcast
        top_signame: ast_intraip_p2s
        index: -1
        external: true
        conn_type: false
      }
      {
        name: intraip_s2p
        desc: Secondary-to-Primary partition communication
        struct: s2p
        package: ast_intraip_pkg
        type: uni
        act: req
        width: 1
        partition: secondary
        inst_name: ast
        default: ""
        end_idx: -1
        top_type: broadcast
        top_signame: ast_intraip_s2p
        index: -1
        external: true
        conn_type: false
      }
      {
        name: intraip_p2s
        desc: Primary-to-Secondary partition communication
        struct: p2s
        package: ast_intraip_pkg
        type: uni
        act: rcv
        width: 1
        partition: secondary
        inst_name: ast
        default: ""
        domain: Aon
        top_signame: ast_intraip_p2s
        index: -1
        external: true
        conn_type: false
      }
      {
        name: tl
        struct: tl
        package: tlul_pkg
        type: req_rsp
        act: rsp
        width: 1
        inst_name: ast
        default: ""
        end_idx: -1
        top_type: one-to-one
        top_signame: ast_tl
        index: -1
      }
      {
        name: ast_alert
        struct: ast_alert
        package: ast_pkg
        type: req_rsp
        act: rsp
        width: 1
        inst_name: sensor_ctrl
        default: ""
        end_idx: -1
        top_type: one-to-one
        top_signame: sensor_ctrl_ast_alert
        index: -1
      }
      {
        name: ast_status
        struct: ast_status
        package: ast_pkg
        type: uni
        act: rcv
        width: 1
        inst_name: sensor_ctrl
        default: ""
        domain: Aon
        top_signame: ast_io_pwr_st
        index: -1
      }
      {
        name: ast_init_done
        struct: mubi4
        package: prim_mubi_pkg
        type: uni
        act: rcv
        width: 1
        default: prim_mubi_pkg::MuBi4True
        inst_name: sensor_ctrl
        domain: Aon
        top_signame: ast_init_done
        index: -1
        external: true
        conn_type: false
      }
      {
        name: ast2pinmux
        struct: logic
        type: uni
        act: rcv
        width: 9
        inst_name: sensor_ctrl
        default: ""
        package: ""
        domain: Aon
        top_signame: ast_ast2padmux
        index: -1
      }
      {
        name: wkup_req
        struct: logic
        type: uni
        act: req
        width: 1
        inst_name: sensor_ctrl
        default: ""
        package: ""
        domain: Aon
        top_signame: pwrmgr_wakeups
        index: 7
      }
      {
        name: manual_pad_attr
        struct: pad_attr
        package: prim_pad_wrapper_pkg
        type: uni
        act: req
        width: 4
        default: "'0"
        inst_name: sensor_ctrl
        external: true
        conn_type: false
        index: -1
        top_signame: sensor_ctrl_manual_pad_attr
      }
      {
        name: tl
        struct: tl
        package: tlul_pkg
        type: req_rsp
        act: rsp
        width: 1
        inst_name: sensor_ctrl
        default: ""
        end_idx: -1
        top_type: one-to-one
        top_signame: sensor_ctrl_tl
        index: -1
        external: true
        conn_type: false
      }
      {
        name: sram_otp_key
        struct: sram_otp_key
        package: otp_ctrl_pkg
        type: req_rsp
        act: req
        width: 1
        inst_name: sram_ctrl_ret
        default: ""
        domain: Aon
        top_signame: otp_ctrl_sram_otp_key
        index: -1
        external: true
        conn_type: false
      }
      {
        name: ram_cfg
        struct: ram_1p_cfg
        package: prim_ram_1p_pkg
        type: req_rsp
        act: rsp
        width:
        {
          name: NumRamInst
          desc: Number of internal RAM instances. Must be the same as ceil(MemSizeRam / InstSize) .
          param_type: int
          unpacked_dimensions: null
          default: 1
          local: false
          expose: true
          name_top: SramCtrlRetNumRamInst
        }
        inst_name: sram_ctrl_ret
        default: ""
        top_signame: sram_ctrl_ret_ram_cfg
        index: -1
      }
      {
        name: lc_escalate_en
        struct: lc_tx
        package: lc_ctrl_pkg
        type: uni
        act: rcv
        width: 1
        default: lc_ctrl_pkg::Off
        inst_name: sram_ctrl_ret
        domain: Aon
        top_signame: lc_ctrl_lc_escalate_en
        index: -1
        external: true
        conn_type: false
      }
      {
        name: lc_hw_debug_en
        struct: lc_tx
        package: lc_ctrl_pkg
        type: uni
        act: rcv
        width: 1
        default: lc_ctrl_pkg::Off
        inst_name: sram_ctrl_ret
        index: -1
      }
      {
        name: otp_en_sram_ifetch
        struct: mubi8
        package: prim_mubi_pkg
        type: uni
        act: rcv
        width: 1
        default: prim_mubi_pkg::MuBi8False
        inst_name: sram_ctrl_ret
        index: -1
      }
      {
        name: racl_policies
        desc:
          '''
          Incoming RACL policy vector from a racl_ctrl instance.
          The policy selection vector (parameter) selects the policy for each register.
          '''
        struct: racl_policy_vec
        package: top_racl_pkg
        type: uni
        act: rcv
        width: 1
        inst_name: sram_ctrl_ret
        index: -1
      }
      {
        name: racl_error
        desc: RACL error log information of this module.
        struct: racl_error_log
        package: top_racl_pkg
        type: uni
        act: req
        width: 1
        inst_name: sram_ctrl_ret
        index: -1
      }
      {
        name: sram_rerror
        desc: SRAM read error indicating correctable and uncorrectable ECC errors.
        struct: sram_error_t
        package: sram_ctrl_pkg
        type: uni
        act: req
        width: 1
        inst_name: sram_ctrl_ret
        index: -1
      }
      {
        name: regs_tl
        struct: tl
        package: tlul_pkg
        type: req_rsp
        act: rsp
        width: 1
        inst_name: sram_ctrl_ret
        default: ""
        end_idx: -1
        top_type: one-to-one
        top_signame: sram_ctrl_ret_regs_tl
        index: -1
        external: true
        conn_type: false
      }
      {
        name: ram_tl
        struct: tl
        package: tlul_pkg
        type: req_rsp
        act: rsp
        width: 1
        inst_name: sram_ctrl_ret
        default: ""
        end_idx: -1
        top_type: one-to-one
        top_signame: sram_ctrl_ret_ram_tl
        index: -1
        external: true
        conn_type: false
      }
      {
        name: rram_macro
        struct: rram_macro
        package: rram_ctrl_pkg
        type: req_rsp
        act: req
        width: 1
        inst_name: rram_ctrl
        default: ""
        end_idx: -1
        top_type: one-to-one
        top_signame: rram_ctrl_rram_macro
        index: -1
      }
      {
        name: otp_key
        struct: nvm_otp_key
        package: otp_ctrl_pkg
        type: req_rsp
        act: req
        width: 1
        inst_name: rram_ctrl
        default: ""
        end_idx: -1
        top_type: one-to-one
        top_signame: rram_ctrl_otp_key
        index: -1
      }
      {
        name: otp_macro
        desc: Data interface for the OTP macro.
        struct: otp_ctrl_macro
        package: otp_ctrl_macro_pkg
        type: req_rsp
        act: rsp
        width: 1
        default: "'0"
        inst_name: rram_ctrl
        domain: Main
        top_signame: otp_ctrl_otp_macro
        index: -1
      }
      {
        name: lc_creator_seed_sw_rw_en
        struct: lc_tx
        package: lc_ctrl_pkg
        type: uni
        act: rcv
        width: 1
        inst_name: rram_ctrl
        default: ""
        domain: Main
        top_signame: lc_ctrl_lc_creator_seed_sw_rw_en
        index: -1
      }
      {
        name: lc_owner_seed_sw_rw_en
        struct: lc_tx
        package: lc_ctrl_pkg
        type: uni
        act: rcv
        width: 1
        inst_name: rram_ctrl
        default: ""
        domain: Main
        top_signame: lc_ctrl_lc_owner_seed_sw_rw_en
        index: -1
      }
      {
        name: lc_iso_part_sw_rd_en
        struct: lc_tx
        package: lc_ctrl_pkg
        type: uni
        act: rcv
        width: 1
        inst_name: rram_ctrl
        default: ""
        domain: Main
        top_signame: lc_ctrl_lc_iso_part_sw_rd_en
        index: -1
      }
      {
        name: lc_iso_part_sw_wr_en
        struct: lc_tx
        package: lc_ctrl_pkg
        type: uni
        act: rcv
        width: 1
        inst_name: rram_ctrl
        default: ""
        domain: Main
        top_signame: lc_ctrl_lc_iso_part_sw_wr_en
        index: -1
      }
      {
        name: lc_seed_hw_rd_en
        struct: lc_tx
        package: lc_ctrl_pkg
        type: uni
        act: rcv
        width: 1
        inst_name: rram_ctrl
        default: ""
        domain: Main
        top_signame: lc_ctrl_lc_seed_hw_rd_en
        index: -1
      }
      {
        name: lc_escalate_en
        struct: lc_tx
        package: lc_ctrl_pkg
        type: uni
        act: rcv
        width: 1
        inst_name: rram_ctrl
        default: ""
        domain: Main
        top_signame: lc_ctrl_lc_escalate_en
        index: -1
      }
      {
        name: rma_req
        struct: lc_tx
        package: lc_ctrl_pkg
        type: uni
        act: rcv
        width: 1
        inst_name: rram_ctrl
        default: ""
        domain: Main
        top_signame: lc_ctrl_lc_nvm_rma_req
        index: -1
      }
      {
        name: rma_ack
        struct: lc_tx
        package: lc_ctrl_pkg
        type: uni
        act: req
        width: 1
        inst_name: rram_ctrl
        default: ""
        domain: Main
        top_signame: lc_ctrl_lc_nvm_rma_ack
        index: 0
      }
      {
        name: rma_seed
        struct: lc_nvm_rma_seed
        package: lc_ctrl_pkg
        type: uni
        act: rcv
        width: 1
        inst_name: rram_ctrl
        default: ""
        domain: Main
        top_signame: lc_ctrl_lc_nvm_rma_seed
        index: -1
      }
      {
        name: pwrmgr
        struct: pwr_nvm
        package: pwrmgr_pkg
        type: uni
        act: req
        width: 1
        inst_name: rram_ctrl
        default: ""
        domain: Main
        top_signame: pwrmgr_pwr_nvm
        index: -1
        external: true
        conn_type: false
      }
      {
        name: keymgr_creator_seed
        desc: Creator seed output to the key manager
        struct: keymgr_dpe_creator_seed
        package: keymgr_dpe_pkg
        type: uni
        act: req
        width: 1
        default: "'0"
        inst_name: rram_ctrl
        end_idx: -1
        top_type: broadcast
        top_signame: rram_ctrl_keymgr_creator_seed
        index: -1
      }
      {
        name: keymgr_owner_seed
        desc: Owner seed output to the key manager
        struct: keymgr_dpe_owner_seed
        package: keymgr_dpe_pkg
        type: uni
        act: req
        width: 1
        default: "'0"
        inst_name: rram_ctrl
        end_idx: -1
        top_type: broadcast
        top_signame: rram_ctrl_keymgr_owner_seed
        index: -1
      }
      {
        name: core_tl
        struct: tl
        package: tlul_pkg
        type: req_rsp
        act: rsp
        width: 1
        inst_name: rram_ctrl
        default: ""
        end_idx: -1
        top_type: one-to-one
        top_signame: rram_ctrl_core_tl
        index: -1
      }
      {
        name: host_tl
        struct: tl
        package: tlul_pkg
        type: req_rsp
        act: rsp
        width: 1
        inst_name: rram_ctrl
        default: ""
        end_idx: -1
        top_type: one-to-one
        top_signame: rram_ctrl_host_tl
        index: -1
      }
      {
        name: rram_macro
        struct: rram_macro
        package: rram_ctrl_pkg
        type: req_rsp
        act: rsp
        width: 1
        inst_name: rram_macro
        default: ""
        domain: Main
        top_signame: rram_ctrl_rram_macro
        index: -1
      }
      {
        name: lc_nvm_debug_en
        struct: lc_tx
        package: lc_ctrl_pkg
        type: uni
        act: rcv
        width: 1
        inst_name: rram_macro
        default: ""
        domain: Main
        top_signame: lc_ctrl_lc_nvm_debug_en
        index: -1
      }
      {
        name: jtag
        desc: JTAG signals for the RRAM TAP.
        struct: jtag
        package: jtag_pkg
        type: req_rsp
        act: rsp
        width: 1
        inst_name: rram_macro
        default: ""
        domain: Main
        top_signame: pinmux_rram_jtag
        index: -1
        external: true
        conn_type: false
      }
      {
        name: obs_ctrl
        desc: AST observability control signals.
        struct: ast_obs_ctrl
        package: ast_pkg
        type: uni
        act: rcv
        width: 1
        inst_name: rram_macro
        default: ""
        domain: Main
        top_signame: ast_obs_ctrl
        index: -1
        external: true
        conn_type: false
      }
      {
        name: rram_obs
        desc: AST observability bus.
        struct: logic
        type: uni
        act: req
        width: 8
        inst_name: rram_macro
        index: -1
      }
      {
        name: rram_test_analog
        struct: ""
        type: io
        act: none
        width: 1
        default: "'0"
        inst_name: rram_macro
        package: ""
        external: true
        conn_type: false
        index: -1
        top_signame: rram_test_analog
      }
      {
        name: prim_tl
        struct: tl
        package: tlul_pkg
        type: req_rsp
        act: rsp
        width: 1
        inst_name: rram_macro
        default: ""
        end_idx: -1
        top_type: one-to-one
        top_signame: rram_macro_prim_tl
        index: -1
      }
      {
        name: next_dm_addr
        desc:
          '''
          32bit word address of the next debug module.
          Set to 0x0 if this is the last debug module in the chain.
          '''
        struct: next_dm_addr
        package: rv_dm_pkg
        type: uni
        act: rcv
        width: 1
        default: "'0"
        inst_name: rv_dm
        index: -1
      }
      {
        name: jtag
        desc: JTAG signals for the RISC-V TAP.
        struct: jtag
        package: jtag_pkg
        type: req_rsp
        act: rsp
        width: 1
        inst_name: rv_dm
        default: ""
        domain: Main
        top_signame: pinmux_rv_jtag
        index: -1
        external: true
        conn_type: false
      }
      {
        name: cheriot_ena
        desc:
          '''
          CHERIoT mode enable.
          Selects which ROM and which abstract command encodings the debug module uses.
          Ignored unless CheriotSupport is set.
          '''
        struct: mubi4
        package: prim_mubi_pkg
        type: uni
        act: rcv
        width: 1
        default: prim_mubi_pkg::MuBi4False
        inst_name: rv_dm
        domain: Main
        top_signame: rv_core_ibex_cheriot_ena
        index: -1
      }
      {
        name: lc_init_done
        desc: Lifecycle initialization done signal coming from life cycle controller.
        struct: lc_tx
        package: lc_ctrl_pkg
        type: uni
        act: rcv
        width: 1
        default: lc_ctrl_pkg::Off
        inst_name: rv_dm
        domain: Main
        top_signame: lc_ctrl_lc_init_done
        index: -1
      }
      {
        name: lc_hw_debug_clr
        desc:
          '''
          Multibit life cycle hardware debug clear signal coming from life cycle controller,
          asserted when the hardware debug mechanism was enabled and gets disabled.
          '''
        struct: lc_tx
        package: lc_ctrl_pkg
        type: uni
        act: rcv
        width: 1
        default: lc_ctrl_pkg::Off
        inst_name: rv_dm
        domain: Main
        top_signame: lc_ctrl_lc_hw_debug_clr
        index: -1
      }
      {
        name: lc_hw_debug_en
        desc:
          '''
          Multibit life cycle hardware debug enable signal coming from life cycle controller,
          asserted when the hardware debug mechanisms are enabled in the system.
          '''
        struct: lc_tx
        package: lc_ctrl_pkg
        type: uni
        act: rcv
        width: 1
        default: lc_ctrl_pkg::Off
        inst_name: rv_dm
        domain: Main
        top_signame: lc_ctrl_lc_hw_debug_en
        index: -1
      }
      {
        name: lc_dft_en
        desc:
          '''
          Multibit life cycle hardware debug enable signal coming from life cycle controller,
          asserted when the DFT mechanisms are enabled in the system.
          '''
        struct: lc_tx
        package: lc_ctrl_pkg
        type: uni
        act: rcv
        width: 1
        default: lc_ctrl_pkg::Off
        inst_name: rv_dm
        domain: Main
        top_signame: lc_ctrl_lc_dft_en
        index: -1
      }
      {
        name: pinmux_hw_debug_en
        desc:
          '''
          Multibit life cycle hardware debug enable signal coming from pinmux.
          This is a latched version of the lc_hw_debug_en signal and is only used to
          gate the JTAG / TAP side of the RV_DM. It is used to keep a debug session live
          while the rest of the system undergoes an NDM reset.
          '''
        struct: lc_tx
        package: lc_ctrl_pkg
        type: uni
        act: rcv
        width: 1
        default: lc_ctrl_pkg::Off
        inst_name: rv_dm
        domain: Main
        top_signame: pinmux_pinmux_hw_debug_en
        index: -1
        external: true
        conn_type: false
      }
      {
        name: otp_dis_rv_dm_late_debug
        struct: mubi8
        package: prim_mubi_pkg
        type: uni
        act: rcv
        width: 1
        default: prim_mubi_pkg::MuBi8False
        inst_name: rv_dm
        top_signame: rv_dm_otp_dis_rv_dm_late_debug
        index: -1
      }
      {
        name: unavailable
        desc:
          '''
          This signal indicates to the debug module that the main processor is not available
          for debug (e.g. due to a low-power state).
          '''
        struct: logic
        type: uni
        act: rcv
        width: 1
        default: 1'b0
        inst_name: rv_dm
        index: -1
      }
      {
        name: ndmreset_req
        desc: Non-debug module reset request going to the system reset infrastructure.
        struct: logic
        type: uni
        act: req
        width: 1
        inst_name: rv_dm
        default: ""
        package: ""
        end_idx: -1
        top_type: broadcast
        top_signame: rv_dm_ndmreset_req
        index: -1
        external: true
        conn_type: false
      }
      {
        name: dmactive
        desc:
          '''
          This signal indicates whether the debug module is active and can be used to prevent
          power down of the core and bus-attached peripherals.
          '''
        struct: logic
        type: uni
        act: req
        width: 1
        inst_name: rv_dm
        index: -1
      }
      {
        name: debug_req
        desc: This is the debug request interrupt going to the main processor.
        struct: logic [rv_dm_reg_pkg::NrHarts-1:0]
        type: uni
        act: req
        width: 1
        inst_name: rv_dm
        default: ""
        package: ""
        end_idx: -1
        top_type: broadcast
        top_signame: rv_dm_debug_req
        index: -1
      }
      {
        name: lc_escalate_en
        desc:
          '''
          Escalation enable signal coming from life cycle controller, used for invalidating
          the latched lc_hw_debug_en state inside the strap sampling logic.
          '''
        struct: lc_tx
        package: lc_ctrl_pkg
        type: uni
        act: rcv
        width: 1
        default: lc_ctrl_pkg::Off
        inst_name: rv_dm
        index: -1
      }
      {
        name: lc_check_byp_en
        desc:
          '''
          Check bypass enable signal coming from life cycle controller, used for invalidating
          the latched lc_hw_debug_en state inside the strap sampling logic. This signal is asserted
          whenever the life cycle controller performs a life cycle transition. Its main use is
          to skip any background checks inside the life cycle partition of the OTP controller while
          a life cycle transition is in progress.
          '''
        struct: lc_tx
        package: lc_ctrl_pkg
        type: uni
        act: rcv
        width: 1
        default: lc_ctrl_pkg::Off
        inst_name: rv_dm
        index: -1
      }
      {
        name: strap_en
        desc: This signal is pulsed high by the power manager after reset in order to sample the HW straps.
        struct: logic
        type: uni
        act: rcv
        width: 1
        default: 1'b0
        inst_name: rv_dm
        index: -1
      }
      {
        name: strap_en_override
        desc:
          '''
          This signal transitions from 0 -> 1 by the lc_ctrl manager after volatile RAW_UNLOCK in order to re-sample the HW straps.
          The signal must stay at 1 until reset.
          Note that this is only used in test chips when SecVolatileRawUnlockEn = 1.
          Otherwise this signal is unused.
          '''
        struct: logic
        type: uni
        act: rcv
        width: 1
        default: 1'b0
        inst_name: rv_dm
        index: -1
      }
      {
        name: racl_policies
        desc:
          '''
          Incoming RACL policy vector from a racl_ctrl instance.
          The policy selection vector (parameter) selects the policy for each register.
          '''
        struct: racl_policy_vec
        package: top_racl_pkg
        type: uni
        act: rcv
        width: 1
        inst_name: rv_dm
        index: -1
      }
      {
        name: racl_error
        desc: RACL error log information of this module.
        struct: racl_error_log
        package: top_racl_pkg
        type: uni
        act: req
        width: 1
        inst_name: rv_dm
        index: -1
      }
      {
        name: sba_tl_h
        struct: tl
        package: tlul_pkg
        type: req_rsp
        act: req
        width: 1
        inst_name: rv_dm
        default: ""
        domain: Main
        top_signame: main_tl_rv_dm__sba
        index: -1
      }
      {
        name: regs_tl_d
        struct: tl
        package: tlul_pkg
        type: req_rsp
        act: rsp
        width: 1
        inst_name: rv_dm
        default: ""
        end_idx: -1
        top_type: one-to-one
        top_signame: rv_dm_regs_tl_d
        index: -1
      }
      {
        name: mem_tl_d
        struct: tl
        package: tlul_pkg
        type: req_rsp
        act: rsp
        width: 1
        inst_name: rv_dm
        default: ""
        end_idx: -1
        top_type: one-to-one
        top_signame: rv_dm_mem_tl_d
        index: -1
      }
      {
        name: dbg_tl_d
        struct: tl
        package: tlul_pkg
        type: req_rsp
        act: rsp
        width: 1
        inst_name: rv_dm
        index: -1
      }
      {
        name: irq
        struct: logic
        type: uni
        act: req
        width: 1
        inst_name: rv_plic
        default: ""
        package: ""
        end_idx: -1
        top_type: broadcast
        top_signame: rv_plic_irq
        index: -1
      }
      {
        name: irq_id
        struct: logic
        type: uni
        act: req
        width: 1
        inst_name: rv_plic
        index: -1
      }
      {
        name: msip
        struct: logic
        type: uni
        act: req
        width: 1
        inst_name: rv_plic
        default: ""
        package: ""
        end_idx: -1
        top_type: broadcast
        top_signame: rv_plic_msip
        index: -1
      }
      {
        name: tl
        struct: tl
        package: tlul_pkg
        type: req_rsp
        act: rsp
        width: 1
        inst_name: rv_plic
        default: ""
        end_idx: -1
        top_type: one-to-one
        top_signame: rv_plic_tl
        index: -1
      }
      {
        name: idle
        struct: mubi4
        package: prim_mubi_pkg
        type: uni
        act: req
        width: 1
        inst_name: aes
        default: ""
        domain: Main
        top_signame: clkmgr_idle
        index: 0
        external: true
        conn_type: false
      }
      {
        name: output_valid
        struct: logic
        type: uni
        act: req
        width: 1
        inst_name: aes
        index: -1
      }
      {
        name: input_ready
        struct: logic
        type: uni
        act: req
        width: 1
        inst_name: aes
        index: -1
      }
      {
        name: lc_escalate_en
        struct: lc_tx
        package: lc_ctrl_pkg
        type: uni
        act: rcv
        width: 1
        default: lc_ctrl_pkg::Off
        inst_name: aes
        domain: Main
        top_signame: lc_ctrl_lc_escalate_en
        index: -1
      }
      {
        name: edn
        struct: edn
        package: edn_pkg
        type: req_rsp
        act: req
        width: 1
        inst_name: aes
        default: ""
        domain: Main
        top_signame: edn0_edn
        index: 5
      }
      {
        name: keymgr_key
        struct: hw_key_req
        package: keymgr_dpe_pkg
        type: uni
        act: rcv
        width: 1
        inst_name: aes
        default: ""
        domain: Main
        top_signame: keymgr_dpe_aes_key
        index: -1
      }
      {
        name: tl
        struct: tl
        package: tlul_pkg
        type: req_rsp
        act: rsp
        width: 1
        inst_name: aes
        default: ""
        end_idx: -1
        top_type: one-to-one
        top_signame: aes_tl
        index: -1
      }
      {
        name: idle
        struct: mubi4
        package: prim_mubi_pkg
        type: uni
        act: req
        width: 1
        inst_name: hmac
        default: ""
        domain: Main
        top_signame: clkmgr_idle
        index: 1
        external: true
        conn_type: false
      }
      {
        name: keymgr_key
        struct: wide_hw_key_req
        package: keymgr_dpe_pkg
        type: uni
        act: rcv
        width: 1
        inst_name: hmac
        default: ""
        domain: Main
        top_signame: keymgr_dpe_hmac_key
        index: -1
      }
      {
        name: tl
        struct: tl
        package: tlul_pkg
        type: req_rsp
        act: rsp
        width: 1
        inst_name: hmac
        default: ""
        end_idx: -1
        top_type: one-to-one
        top_signame: hmac_tl
        index: -1
      }
      {
        name: keymgr_key
        struct: hw_key_req
        package: keymgr_dpe_pkg
        type: uni
        act: rcv
        width: 1
        inst_name: kmac
        default: ""
        domain: Main
        top_signame: keymgr_dpe_kmac_key
        index: -1
      }
      {
        name: app
        struct: app
        package: kmac_pkg
        type: req_rsp
        act: rsp
        width:
        {
          name: NumAppIntf
          desc: Number of application interfaces
          param_type: int
          unpacked_dimensions: null
          default: 4
          local: false
          expose: true
          name_top: KmacNumAppIntf
        }
        default: kmac_pkg::APP_REQ_DEFAULT
        inst_name: kmac
        end_idx: -1
        top_type: one-to-N
        top_signame: kmac_app
        index: -1
      }
      {
        name: entropy
        struct: edn
        package: edn_pkg
        type: req_rsp
        act: req
        width: 1
        inst_name: kmac
        default: ""
        domain: Main
        top_signame: edn0_edn
        index: 3
      }
      {
        name: idle
        struct: mubi4
        package: prim_mubi_pkg
        type: uni
        act: req
        width: 1
        inst_name: kmac
        default: ""
        domain: Main
        top_signame: clkmgr_idle
        index: 2
        external: true
        conn_type: false
      }
      {
        name: en_masking
        struct: logic
        type: uni
        act: req
        width: 1
        inst_name: kmac
        default: ""
        package: ""
        end_idx: -1
        top_type: broadcast
        top_signame: kmac_en_masking
        index: -1
      }
      {
        name: lc_escalate_en
        struct: lc_tx
        package: lc_ctrl_pkg
        type: uni
        act: rcv
        width: 1
        default: lc_ctrl_pkg::Off
        inst_name: kmac
        domain: Main
        top_signame: lc_ctrl_lc_escalate_en
        index: -1
      }
      {
        name: tl
        struct: tl
        package: tlul_pkg
        type: req_rsp
        act: rsp
        width: 1
        inst_name: kmac
        default: ""
        end_idx: -1
        top_type: one-to-one
        top_signame: kmac_tl
        index: -1
      }
      {
        name: otbn_otp_key
        struct: otbn_otp_key
        package: otp_ctrl_pkg
        type: req_rsp
        act: req
        width: 1
        default: "'0"
        inst_name: otbn
        domain: Main
        top_signame: otp_ctrl_otbn_otp_key
        index: -1
      }
      {
        name: edn_rnd
        struct: edn
        package: edn_pkg
        type: req_rsp
        act: req
        width: 1
        inst_name: otbn
        default: ""
        domain: Main
        top_signame: edn1_edn
        index: 0
      }
      {
        name: edn_urnd
        struct: edn
        package: edn_pkg
        type: req_rsp
        act: req
        width: 1
        inst_name: otbn
        default: ""
        domain: Main
        top_signame: edn0_edn
        index: 6
      }
      {
        name: idle
        struct: mubi4
        package: prim_mubi_pkg
        type: uni
        act: req
        width: 1
        inst_name: otbn
        default: ""
        domain: Main
        top_signame: clkmgr_idle
        index: 3
        external: true
        conn_type: false
      }
      {
        name: ram_cfg_imem
        struct: ram_1p_cfg
        package: prim_ram_1p_pkg
        type: req_rsp
        act: rsp
        width: 1
        inst_name: otbn
        default: ""
        top_signame: otbn_ram_cfg_imem
        index: -1
      }
      {
        name: ram_cfg_dmem
        struct: ram_1p_cfg
        package: prim_ram_1p_pkg
        type: req_rsp
        act: rsp
        width: 1
        inst_name: otbn
        default: ""
        top_signame: otbn_ram_cfg_dmem
        index: -1
      }
      {
        name: lc_escalate_en
        struct: lc_tx
        package: lc_ctrl_pkg
        type: uni
        act: rcv
        width: 1
        default: lc_ctrl_pkg::Off
        inst_name: otbn
        domain: Main
        top_signame: lc_ctrl_lc_escalate_en
        index: -1
      }
      {
        name: lc_rma_req
        struct: lc_tx
        package: lc_ctrl_pkg
        type: uni
        act: rcv
        width: 1
        default: lc_ctrl_pkg::Off
        inst_name: otbn
        domain: Main
        top_signame: lc_ctrl_lc_nvm_rma_req
        index: -1
      }
      {
        name: lc_rma_ack
        struct: lc_tx
        package: lc_ctrl_pkg
        type: uni
        act: req
        width: 1
        default: lc_ctrl_pkg::Off
        inst_name: otbn
        domain: Main
        top_signame: lc_ctrl_lc_nvm_rma_ack
        index: 1
      }
      {
        name: keymgr_key
        struct: wide_hw_key_req
        package: keymgr_dpe_pkg
        type: uni
        act: rcv
        width: 1
        inst_name: otbn
        default: ""
        domain: Main
        top_signame: keymgr_dpe_otbn_key
        index: -1
      }
      {
        name: kmac_app
        struct: app
        package: kmac_pkg
        type: req_rsp
        act: req
        width: 1
        inst_name: otbn
        default: ""
        domain: Main
        top_signame: kmac_app
        index: 3
      }
      {
        name: keymgr_app
        struct: app
        package: kmac_pkg
        type: req_rsp
        act: rsp
        width: 1
        inst_name: otbn
        default: ""
        end_idx: -1
        top_type: one-to-one
        top_signame: otbn_keymgr_app
        index: -1
      }
      {
        name: keymgr_sensitive_key
        struct: mubi4
        package: prim_mubi_pkg
        type: uni
        act: rcv
        width: 1
        default: prim_mubi_pkg::MuBi4False
        inst_name: otbn
        end_idx: -1
        top_type: broadcast
        top_signame: otbn_keymgr_sensitive_key
        index: -1
      }
      {
        name: tl
        struct: tl
        package: tlul_pkg
        type: req_rsp
        act: rsp
        width: 1
        inst_name: otbn
        default: ""
        end_idx: -1
        top_type: one-to-one
        top_signame: otbn_tl
        index: -1
      }
      {
        name: edn
        struct: edn
        package: edn_pkg
        type: req_rsp
        act: req
        width: 1
        inst_name: keymgr_dpe
        default: ""
        domain: Main
        top_signame: edn0_edn
        index: 0
      }
      {
        name: aes_key
        struct: hw_key_req
        package: keymgr_dpe_pkg
        type: uni
        act: req
        width: 1
        inst_name: keymgr_dpe
        default: ""
        end_idx: -1
        top_type: broadcast
        top_signame: keymgr_dpe_aes_key
        index: -1
      }
      {
        name: kmac_key
        struct: hw_key_req
        package: keymgr_dpe_pkg
        type: uni
        act: req
        width: 1
        inst_name: keymgr_dpe
        default: ""
        end_idx: -1
        top_type: broadcast
        top_signame: keymgr_dpe_kmac_key
        index: -1
      }
      {
        name: hmac_key
        struct: wide_hw_key_req
        package: keymgr_dpe_pkg
        type: uni
        act: req
        width: 1
        inst_name: keymgr_dpe
        default: ""
        end_idx: -1
        top_type: broadcast
        top_signame: keymgr_dpe_hmac_key
        index: -1
      }
      {
        name: otbn_key
        struct: wide_hw_key_req
        package: keymgr_dpe_pkg
        type: uni
        act: req
        width: 1
        inst_name: keymgr_dpe
        default: ""
        end_idx: -1
        top_type: broadcast
        top_signame: keymgr_dpe_otbn_key
        index: -1
      }
      {
        name: kmac_app
        struct: app
        package: kmac_pkg
        type: req_rsp
        act: req
        width: 1
        inst_name: keymgr_dpe
        default: ""
        domain: Main
        top_signame: kmac_app
        index: 0
      }
      {
        name: otbn_app
        struct: app
        package: kmac_pkg
        type: req_rsp
        act: req
        width: 1
        inst_name: keymgr_dpe
        default: ""
        domain: Main
        top_signame: otbn_keymgr_app
        index: -1
      }
      {
        name: sensitive_key
        struct: mubi4
        package: prim_mubi_pkg
        type: uni
        act: req
        width: 1
        default: prim_mubi_pkg::MuBi4False
        inst_name: keymgr_dpe
        domain: Main
        top_signame: otbn_keymgr_sensitive_key
        index: -1
      }
      {
        name: creator_root_key
        struct: keymgr_dpe_creator_root_key
        package: keymgr_dpe_pkg
        type: uni
        act: rcv
        width: 1
        inst_name: keymgr_dpe
        default: ""
        domain: Main
        top_signame: otp_ctrl_keymgr_creator_root_key
        index: -1
      }
      {
        name: secondary_root_key
        struct: keymgr_dpe_creator_root_key
        package: keymgr_dpe_pkg
        type: uni
        act: rcv
        width: 1
        default: keymgr_dpe_pkg::KEYMGR_DPE_SECONDARY_ROOT_KEY_DEFAULT
        inst_name: keymgr_dpe
        index: -1
      }
      {
        name: creator_seed
        struct: keymgr_dpe_creator_seed
        package: keymgr_dpe_pkg
        type: uni
        act: rcv
        width: 1
        inst_name: keymgr_dpe
        default: ""
        domain: Main
        top_signame: rram_ctrl_keymgr_creator_seed
        index: -1
      }
      {
        name: owner_seed
        struct: keymgr_dpe_owner_seed
        package: keymgr_dpe_pkg
        type: uni
        act: rcv
        width: 1
        inst_name: keymgr_dpe
        default: ""
        domain: Main
        top_signame: rram_ctrl_keymgr_owner_seed
        index: -1
      }
      {
        name: device_id
        struct: keymgr_dpe_device_id
        package: keymgr_dpe_pkg
        type: uni
        act: rcv
        width: 1
        inst_name: keymgr_dpe
        default: ""
        top_signame: keymgr_dpe_device_id
        index: -1
      }
      {
        name: field_entropy
        struct: keymgr_dpe_field_entropy
        package: keymgr_dpe_pkg
        type: uni
        act: rcv
        width: 1
        inst_name: keymgr_dpe
        index: -1
      }
      {
        name: lc_keymgr_en
        struct: lc_tx
        package: lc_ctrl_pkg
        type: uni
        act: rcv
        width: 1
        default: lc_ctrl_pkg::On
        inst_name: keymgr_dpe
        domain: Main
        top_signame: lc_ctrl_lc_keymgr_en
        index: -1
      }
      {
        name: lc_keymgr_div
        struct: lc_keymgr_div
        package: lc_ctrl_pkg
        type: uni
        act: rcv
        width: 1
        inst_name: keymgr_dpe
        default: ""
        domain: Main
        top_signame: lc_ctrl_lc_keymgr_div
        index: -1
      }
      {
        name: rom_digest
        struct: keymgr_data
        package: rom_ctrl_pkg
        type: uni
        act: rcv
        width:
        {
          name: NumRomDigestInputs
          desc: Number of digest inputs from ROM_CTRL
          param_type: int
          unpacked_dimensions: null
          default: 1
          local: true
          expose: true
          name_top: KeymgrDpeNumRomDigestInputs
        }
        default: rom_ctrl_pkg::KEYMGR_DATA_DEFAULT
        inst_name: keymgr_dpe
        domain: Main
        top_signame: rom_ctrl_keymgr_data
        index: -1
      }
      {
        name: kmac_en_masking
        struct: logic
        type: uni
        act: rcv
        width: 1
        inst_name: keymgr_dpe
        default: ""
        package: ""
        domain: Main
        top_signame: kmac_en_masking
        index: -1
      }
      {
        name: tl
        struct: tl
        package: tlul_pkg
        type: req_rsp
        act: rsp
        width: 1
        inst_name: keymgr_dpe
        default: ""
        end_idx: -1
        top_type: one-to-one
        top_signame: keymgr_dpe_tl
        index: -1
      }
      {
        name: csrng_cmd
        struct: csrng
        package: csrng_pkg
        type: req_rsp
        act: rsp
        width: 2
        inst_name: csrng
        default: ""
        end_idx: -1
        top_type: one-to-N
        top_signame: csrng_csrng_cmd
        index: -1
      }
      {
        name: entropy_src_hw_if
        struct: entropy_src_hw_if
        package: entropy_src_pkg
        type: req_rsp
        act: req
        width: 1
        inst_name: csrng
        default: ""
        end_idx: -1
        top_type: one-to-one
        top_signame: csrng_entropy_src_hw_if
        index: -1
      }
      {
        name: lc_hw_debug_en
        struct: lc_tx
        package: lc_ctrl_pkg
        type: uni
        act: rcv
        width: 1
        default: lc_ctrl_pkg::Off
        inst_name: csrng
        domain: Main
        top_signame: lc_ctrl_lc_hw_debug_en
        index: -1
      }
      {
        name: tl
        struct: tl
        package: tlul_pkg
        type: req_rsp
        act: rsp
        width: 1
        inst_name: csrng
        default: ""
        end_idx: -1
        top_type: one-to-one
        top_signame: csrng_tl
        index: -1
      }
      {
        name: entropy_src_hw_if
        struct: entropy_src_hw_if
        package: entropy_src_pkg
        type: req_rsp
        act: rsp
        width: 1
        inst_name: entropy_src
        default: ""
        domain: Main
        top_signame: csrng_entropy_src_hw_if
        index: -1
      }
      {
        name: entropy_src_rng_enable
        desc:
          '''
          Signal through which entropy_src enables the noise source.
          entropy_src will keep this signal high as long as it expects the noise source to operate.
          This is *not* a flow control signal through which entropy_src would exert backpressure on the noise source; rather this signal stays high while entropy_src is enabled.
          '''
        struct: logic
        type: uni
        act: req
        width: 1
        inst_name: entropy_src
        default: ""
        package: ""
        end_idx: -1
        top_type: broadcast
        top_signame: entropy_src_entropy_src_rng_enable
        index: -1
      }
      {
        name: entropy_src_rng_valid
        desc:
          '''
          Acknowledgement signal from the noise source.
          When '1', it indicates that the `entropy_src_rng_bit` data is valid and ready to be consumed.
          '''
        struct: logic
        type: uni
        act: rcv
        width: 1
        inst_name: entropy_src
        default: ""
        package: ""
        domain: Main
        top_signame: ast_rng_val
        index: -1
      }
      {
        name: entropy_src_rng_bits
        desc:
          '''
          Output data bus carrying the raw entropy bits from the noise source.
          These bits are valid when `entropy_src_rng_valid` is asserted.
          The width is determined by `RngBusWidth` parametrization.
          '''
        struct: logic
        type: uni
        act: rcv
        width:
        {
          name: RngBusWidth
          desc:
            '''
            Defines the bit-width of the noise source data.
            Must be between 4 and 256 (inclusive) and divisible by 4.
            The divisibility by 4 is a prerequisite for the bucket health test.
            '''
          param_type: int
          unpacked_dimensions: null
          default: 4
          local: false
          expose: true
          name_top: EntropySrcRngBusWidth
        }
        inst_name: entropy_src
        default: ""
        package: ""
        domain: Main
        top_signame: ast_rng_b
        index: -1
      }
      {
        name: entropy_src_xht_valid
        desc:
          '''
          Valid signal for the external health test interface.
          When asserted, it indicates that `entropy_src_xht_bits`, `entropy_src_xht_bit_sel`, and `entropy_src_xht_meta` are valid for consumption by the external health test.
          '''
        struct: logic
        type: uni
        act: req
        width: 1
        inst_name: entropy_src
        index: -1
      }
      {
        name: entropy_src_xht_bits
        desc:
          '''
          Carries the raw entropy data from the entropy source to be consumed by the external health test module.
          The data on this bus is valid when `entropy_src_xht_valid` is asserted.
          The width is determined by `RngBusWidth` parametrization.
          '''
        struct: logic
        type: uni
        act: req
        width:
        {
          name: RngBusWidth
          desc:
            '''
            Defines the bit-width of the noise source data.
            Must be between 4 and 256 (inclusive) and divisible by 4.
            The divisibility by 4 is a prerequisite for the bucket health test.
            '''
          param_type: int
          unpacked_dimensions: null
          default: 4
          local: false
          expose: true
          name_top: EntropySrcRngBusWidth
        }
        inst_name: entropy_src
        index: -1
      }
      {
        name: entropy_src_xht_bit_sel
        desc:
          '''
          Provides bit selection information for the raw entropy data.
          It specifies which specific bit or subset of bits from `entropy_src_xht_bit` should be used.
          The width is determined by `RngBusBitSelWidth` parametrization.
          '''
        struct: logic
        type: uni
        act: req
        width:
        {
          name: RngBusBitSelWidth
          desc: Explicit parameter defining the width of the RNG bit selection vector (log2(RngBusWidth))
          param_type: int
          unpacked_dimensions: null
          default: 2
          local: false
          expose: true
          name_top: EntropySrcRngBusBitSelWidth
        }
        inst_name: entropy_src
        index: -1
      }
      {
        name: entropy_src_xht_health_test_window
        desc: Provides the window size of the health in bits.
        struct: logic
        type: uni
        act: req
        width:
        {
          name: HealthTestWindowWidth
          desc: Explicit parameter defining the width of the health test window (16 + log2(RngBusWidth))
          param_type: int
          unpacked_dimensions: null
          default: 18
          local: false
          expose: true
          name_top: EntropySrcHealthTestWindowWidth
        }
        inst_name: entropy_src
        index: -1
      }
      {
        name: entropy_src_xht_meta
        struct: entropy_src_xht_meta
        package: entropy_src_pkg
        type: req_rsp
        act: req
        width: 1
        inst_name: entropy_src
        index: -1
      }
      {
        name: rng_fips
        struct: logic
        type: uni
        act: req
        width: 1
        inst_name: entropy_src
        default: ""
        package: ""
        end_idx: -1
        top_type: broadcast
        top_signame: entropy_src_rng_fips
        index: -1
      }
      {
        name: tl
        struct: tl
        package: tlul_pkg
        type: req_rsp
        act: rsp
        width: 1
        inst_name: entropy_src
        default: ""
        end_idx: -1
        top_type: one-to-one
        top_signame: entropy_src_tl
        index: -1
      }
      {
        name: csrng_cmd
        desc: EDN supports a single CSRNG application interface.
        struct: csrng
        package: csrng_pkg
        type: req_rsp
        act: req
        width: 1
        inst_name: edn0
        default: ""
        domain: Main
        top_signame: csrng_csrng_cmd
        index: 0
      }
      {
        name: edn
        desc: Every endpoint has its own peripheral port.
        struct: edn
        package: edn_pkg
        type: req_rsp
        act: rsp
        width:
        {
          name: NumEndPoints
          desc: Number of endpoints
          param_type: int unsigned
          unpacked_dimensions: null
          default: 8
          local: true
          expose: true
          name_top: Edn0NumEndPoints
        }
        default: "'0"
        inst_name: edn0
        end_idx: -1
        top_type: one-to-N
        top_signame: edn0_edn
        index: -1
      }
      {
        name: tl
        struct: tl
        package: tlul_pkg
        type: req_rsp
        act: rsp
        width: 1
        inst_name: edn0
        default: ""
        end_idx: -1
        top_type: one-to-one
        top_signame: edn0_tl
        index: -1
      }
      {
        name: csrng_cmd
        desc: EDN supports a single CSRNG application interface.
        struct: csrng
        package: csrng_pkg
        type: req_rsp
        act: req
        width: 1
        inst_name: edn1
        default: ""
        domain: Main
        top_signame: csrng_csrng_cmd
        index: 1
      }
      {
        name: edn
        desc: Every endpoint has its own peripheral port.
        struct: edn
        package: edn_pkg
        type: req_rsp
        act: rsp
        width:
        {
          name: NumEndPoints
          desc: Number of endpoints
          param_type: int unsigned
          unpacked_dimensions: null
          default: 8
          local: true
          expose: true
          name_top: Edn1NumEndPoints
        }
        default: "'0"
        inst_name: edn1
        end_idx: -1
        top_type: one-to-one
        top_signame: edn1_edn
        index: -1
      }
      {
        name: tl
        struct: tl
        package: tlul_pkg
        type: req_rsp
        act: rsp
        width: 1
        inst_name: edn1
        default: ""
        end_idx: -1
        top_type: one-to-one
        top_signame: edn1_tl
        index: -1
      }
      {
        name: sram_otp_key
        struct: sram_otp_key
        package: otp_ctrl_pkg
        type: req_rsp
        act: req
        width: 1
        inst_name: sram_ctrl_main
        default: ""
        domain: Main
        top_signame: otp_ctrl_sram_otp_key
        index: 0
      }
      {
        name: ram_cfg
        struct: ram_1p_cfg
        package: prim_ram_1p_pkg
        type: req_rsp
        act: rsp
        width:
        {
          name: NumRamInst
          desc: Number of internal RAM instances. Must be the same as ceil(MemSizeRam / InstSize) .
          param_type: int
          unpacked_dimensions: null
          default: 1
          local: false
          expose: true
          name_top: SramCtrlMainNumRamInst
        }
        inst_name: sram_ctrl_main
        default: ""
        top_signame: sram_ctrl_main_ram_cfg
        index: -1
      }
      {
        name: lc_escalate_en
        struct: lc_tx
        package: lc_ctrl_pkg
        type: uni
        act: rcv
        width: 1
        default: lc_ctrl_pkg::Off
        inst_name: sram_ctrl_main
        domain: Main
        top_signame: lc_ctrl_lc_escalate_en
        index: -1
      }
      {
        name: lc_hw_debug_en
        struct: lc_tx
        package: lc_ctrl_pkg
        type: uni
        act: rcv
        width: 1
        default: lc_ctrl_pkg::Off
        inst_name: sram_ctrl_main
        domain: Main
        top_signame: lc_ctrl_lc_hw_debug_en
        index: -1
      }
      {
        name: otp_en_sram_ifetch
        struct: mubi8
        package: prim_mubi_pkg
        type: uni
        act: rcv
        width: 1
        default: prim_mubi_pkg::MuBi8False
        inst_name: sram_ctrl_main
        top_signame: sram_ctrl_main_otp_en_sram_ifetch
        index: -1
      }
      {
        name: racl_policies
        desc:
          '''
          Incoming RACL policy vector from a racl_ctrl instance.
          The policy selection vector (parameter) selects the policy for each register.
          '''
        struct: racl_policy_vec
        package: top_racl_pkg
        type: uni
        act: rcv
        width: 1
        inst_name: sram_ctrl_main
        index: -1
      }
      {
        name: racl_error
        desc: RACL error log information of this module.
        struct: racl_error_log
        package: top_racl_pkg
        type: uni
        act: req
        width: 1
        inst_name: sram_ctrl_main
        index: -1
      }
      {
        name: sram_rerror
        desc: SRAM read error indicating correctable and uncorrectable ECC errors.
        struct: sram_error_t
        package: sram_ctrl_pkg
        type: uni
        act: req
        width: 1
        inst_name: sram_ctrl_main
        index: -1
      }
      {
        name: regs_tl
        struct: tl
        package: tlul_pkg
        type: req_rsp
        act: rsp
        width: 1
        inst_name: sram_ctrl_main
        default: ""
        end_idx: -1
        top_type: one-to-one
        top_signame: sram_ctrl_main_regs_tl
        index: -1
      }
      {
        name: ram_tl
        struct: tl
        package: tlul_pkg
        type: req_rsp
        act: rsp
        width: 1
        inst_name: sram_ctrl_main
        default: ""
        end_idx: -1
        top_type: one-to-one
        top_signame: sram_ctrl_main_ram_tl
        index: -1
      }
      {
        name: sram_otp_key
        struct: sram_otp_key
        package: otp_ctrl_pkg
        type: req_rsp
        act: req
        width: 1
        inst_name: sram_ctrl_sec
        default: ""
        domain: Main
        top_signame: otp_ctrl_sram_otp_key
        index: 1
      }
      {
        name: ram_cfg
        struct: ram_1p_cfg
        package: prim_ram_1p_pkg
        type: req_rsp
        act: rsp
        width:
        {
          name: NumRamInst
          desc: Number of internal RAM instances. Must be the same as ceil(MemSizeRam / InstSize) .
          param_type: int
          unpacked_dimensions: null
          default: 1
          local: false
          expose: true
          name_top: SramCtrlSecNumRamInst
        }
        inst_name: sram_ctrl_sec
        default: ""
        top_signame: sram_ctrl_sec_ram_cfg
        index: -1
      }
      {
        name: lc_escalate_en
        struct: lc_tx
        package: lc_ctrl_pkg
        type: uni
        act: rcv
        width: 1
        default: lc_ctrl_pkg::Off
        inst_name: sram_ctrl_sec
        domain: Main
        top_signame: lc_ctrl_lc_escalate_en
        index: -1
      }
      {
        name: lc_hw_debug_en
        struct: lc_tx
        package: lc_ctrl_pkg
        type: uni
        act: rcv
        width: 1
        default: lc_ctrl_pkg::Off
        inst_name: sram_ctrl_sec
        domain: Main
        top_signame: lc_ctrl_lc_hw_debug_en
        index: -1
      }
      {
        name: otp_en_sram_ifetch
        struct: mubi8
        package: prim_mubi_pkg
        type: uni
        act: rcv
        width: 1
        default: prim_mubi_pkg::MuBi8False
        inst_name: sram_ctrl_sec
        top_signame: sram_ctrl_sec_otp_en_sram_ifetch
        index: -1
      }
      {
        name: racl_policies
        desc:
          '''
          Incoming RACL policy vector from a racl_ctrl instance.
          The policy selection vector (parameter) selects the policy for each register.
          '''
        struct: racl_policy_vec
        package: top_racl_pkg
        type: uni
        act: rcv
        width: 1
        inst_name: sram_ctrl_sec
        index: -1
      }
      {
        name: racl_error
        desc: RACL error log information of this module.
        struct: racl_error_log
        package: top_racl_pkg
        type: uni
        act: req
        width: 1
        inst_name: sram_ctrl_sec
        index: -1
      }
      {
        name: sram_rerror
        desc: SRAM read error indicating correctable and uncorrectable ECC errors.
        struct: sram_error_t
        package: sram_ctrl_pkg
        type: uni
        act: req
        width: 1
        inst_name: sram_ctrl_sec
        index: -1
      }
      {
        name: regs_tl
        struct: tl
        package: tlul_pkg
        type: req_rsp
        act: rsp
        width: 1
        inst_name: sram_ctrl_sec
        default: ""
        end_idx: -1
        top_type: one-to-one
        top_signame: sram_ctrl_sec_regs_tl
        index: -1
      }
      {
        name: ram_tl
        struct: tl
        package: tlul_pkg
        type: req_rsp
        act: rsp
        width: 1
        inst_name: sram_ctrl_sec
        default: ""
        end_idx: -1
        top_type: one-to-one
        top_signame: sram_ctrl_sec_ram_tl
        index: -1
      }
      {
        name: rom_cfg
        struct: rom_cfg
        package: prim_rom_pkg
        type: req_rsp
        act: rsp
        width: 1
        inst_name: rom_ctrl
        default: ""
        top_signame: rom_ctrl_rom_cfg
        index: -1
      }
      {
        name: pwrmgr_data
        struct: pwrmgr_data
        package: rom_ctrl_pkg
        type: uni
        act: req
        width: 1
        inst_name: rom_ctrl
        default: ""
        end_idx: -1
        top_type: broadcast
        top_signame: rom_ctrl_pwrmgr_data
        index: -1
        external: true
        conn_type: false
      }
      {
        name: keymgr_data
        struct: keymgr_data
        package: rom_ctrl_pkg
        type: uni
        act: req
        width: 1
        inst_name: rom_ctrl
        default: ""
        end_idx: -1
        top_type: broadcast
        top_signame: rom_ctrl_keymgr_data
        index: -1
      }
      {
        name: kmac_data
        struct: app
        package: kmac_pkg
        type: req_rsp
        act: req
        width: 1
        inst_name: rom_ctrl
        default: ""
        domain: Main
        top_signame: kmac_app
        index: 2
      }
      {
        name: regs_tl
        struct: tl
        package: tlul_pkg
        type: req_rsp
        act: rsp
        width: 1
        inst_name: rom_ctrl
        default: ""
        end_idx: -1
        top_type: one-to-one
        top_signame: rom_ctrl_regs_tl
        index: -1
      }
      {
        name: rom_tl
        struct: tl
        package: tlul_pkg
        type: req_rsp
        act: rsp
        width: 1
        inst_name: rom_ctrl
        default: ""
        end_idx: -1
        top_type: one-to-one
        top_signame: rom_ctrl_rom_tl
        index: -1
      }
      {
        name: rst_cpu_n
        struct: logic
        type: uni
        act: req
        width: 1
        inst_name: rv_core_ibex
        index: -1
      }
      {
        name: cheriot_ena
        desc: CHERIoT mode enable.
        struct: mubi4
        package: prim_mubi_pkg
        type: uni
        act: req
        width: 1
        default: prim_mubi_pkg::MuBi4False
        inst_name: rv_core_ibex
        end_idx: -1
        top_type: broadcast
        top_signame: rv_core_ibex_cheriot_ena
        index: -1
      }
      {
        name: cored_tl_h
        desc: Core data host port to the CHERIoT memory subsystem.
        struct: tl
        package: tlul_pkg
        type: req_rsp
        act: req
        width: 1
        inst_name: rv_core_ibex
        default: ""
        end_idx: -1
        top_type: one-to-one
        top_signame: rv_core_ibex_cored_tl_h
        index: -1
      }
      {
        name: cored_tag_h2d
        desc: CHERIoT capability tag carried with the A-channel of cored_tl_h.
        struct: logic
        type: uni
        act: req
        width: 1
        default: 1'b0
        inst_name: rv_core_ibex
        package: ""
        end_idx: -1
        top_type: broadcast
        top_signame: rv_core_ibex_cored_tag_h2d
        index: -1
      }
      {
        name: cored_tag_d2h
        desc: Capability tag returned on the D-channel of cored_tl_h.
        struct: logic
        type: uni
        act: rcv
        width: 1
        default: 1'b0
        inst_name: rv_core_ibex
        package: ""
        domain: Main
        top_signame: cheriot_mem_sys_cored_tag_d2h
        index: -1
      }
      {
        name: corerevbm_tl
        desc: Core revocation bitmap host port.
        struct: tl
        package: tlul_pkg
        type: req_rsp
        act: req
        width: 1
        inst_name: rv_core_ibex
        default: ""
        end_idx: -1
        top_type: one-to-one
        top_signame: rv_core_ibex_corerevbm_tl
        index: -1
      }
      {
        name: ram_cfg_icache_tag
        struct: ram_1p_cfg
        package: prim_ram_1p_pkg
        type: req_rsp
        act: rsp
        width:
        {
          name: ICacheNWays
          desc: Number of instruction cache ways
          param_type: int unsigned
          unpacked_dimensions: null
          default: 2
          local: false
          expose: true
          name_top: RvCoreIbexICacheNWays
        }
        inst_name: rv_core_ibex
        default: ""
        top_signame: rv_core_ibex_ram_cfg_icache_tag
        index: -1
      }
      {
        name: ram_cfg_icache_data
        struct: ram_1p_cfg
        package: prim_ram_1p_pkg
        type: req_rsp
        act: rsp
        width:
        {
          name: ICacheNWays
          desc: Number of instruction cache ways
          param_type: int unsigned
          unpacked_dimensions: null
          default: 2
          local: false
          expose: true
          name_top: RvCoreIbexICacheNWays
        }
        inst_name: rv_core_ibex
        default: ""
        top_signame: rv_core_ibex_ram_cfg_icache_data
        index: -1
      }
      {
        name: hart_id
        struct: logic
        type: uni
        act: rcv
        width: 32
        inst_name: rv_core_ibex
        default: ""
        package: ""
        top_signame: rv_core_ibex_hart_id
        index: -1
      }
      {
        name: boot_addr
        struct: logic
        type: uni
        act: rcv
        width: 32
        inst_name: rv_core_ibex
        default: ""
        package: ""
        top_signame: rv_core_ibex_boot_addr
        index: -1
      }
      {
        name: irq_software
        struct: logic
        type: uni
        act: rcv
        width: 1
        inst_name: rv_core_ibex
        default: ""
        package: ""
        domain: Main
        top_signame: rv_plic_msip
        index: -1
      }
      {
        name: irq_timer
        struct: logic
        type: uni
        act: rcv
        width: 1
        inst_name: rv_core_ibex
        default: ""
        package: ""
        top_signame: rv_core_ibex_irq_timer
        index: -1
      }
      {
        name: irq_external
        struct: logic
        type: uni
        act: rcv
        width: 1
        inst_name: rv_core_ibex
        default: ""
        package: ""
        domain: Main
        top_signame: rv_plic_irq
        index: -1
      }
      {
        name: esc_tx
        struct: esc_tx
        package: prim_esc_pkg
        type: uni
        act: rcv
        width: 1
        inst_name: rv_core_ibex
        default: ""
        domain: Main
        top_signame: alert_handler_esc_tx
        index: 0
      }
      {
        name: esc_rx
        struct: esc_rx
        package: prim_esc_pkg
        type: uni
        act: req
        width: 1
        inst_name: rv_core_ibex
        default: ""
        domain: Main
        top_signame: alert_handler_esc_rx
        index: 0
      }
      {
        name: debug_req
        struct: logic
        type: uni
        act: rcv
        width: 1
        inst_name: rv_core_ibex
        default: ""
        package: ""
        domain: Main
        top_signame: rv_dm_debug_req
        index: -1
      }
      {
        name: crash_dump
        struct: cpu_crash_dump
        package: rv_core_ibex_pkg
        type: uni
        act: req
        width: 1
        inst_name: rv_core_ibex
        default: ""
        end_idx: -1
        top_type: broadcast
        top_signame: rv_core_ibex_crash_dump
        index: -1
        external: true
        conn_type: false
      }
      {
        name: lc_cpu_en
        struct: lc_tx
        package: lc_ctrl_pkg
        type: uni
        act: rcv
        width: 1
        default: lc_ctrl_pkg::On
        inst_name: rv_core_ibex
        domain: Main
        top_signame: lc_ctrl_lc_cpu_en
        index: -1
      }
      {
        name: pwrmgr_cpu_en
        struct: lc_tx
        package: lc_ctrl_pkg
        type: uni
        act: rcv
        width: 1
        inst_name: rv_core_ibex
        default: ""
        domain: Main
        top_signame: pwrmgr_fetch_en
        index: -1
        external: true
        conn_type: false
      }
      {
        name: pwrmgr
        struct: cpu_pwrmgr
        package: rv_core_ibex_pkg
        type: uni
        act: req
        width: 1
        inst_name: rv_core_ibex
        default: ""
        end_idx: -1
        top_type: broadcast
        top_signame: rv_core_ibex_pwrmgr
        index: -1
        external: true
        conn_type: false
      }
      {
        name: nmi_wdog
        struct: logic
        type: uni
        act: rcv
        width: 1
        inst_name: rv_core_ibex
        default: ""
        package: ""
        domain: Main
        top_signame: aon_timer_nmi_wdog_timer_bark
        index: -1
        external: true
        conn_type: false
      }
      {
        name: edn
        struct: edn
        package: edn_pkg
        type: req_rsp
        act: req
        width: 1
        inst_name: rv_core_ibex
        default: ""
        domain: Main
        top_signame: edn0_edn
        index: 7
      }
      {
        name: icache_otp_key
        struct: sram_otp_key
        package: otp_ctrl_pkg
        type: req_rsp
        act: req
        width: 1
        inst_name: rv_core_ibex
        default: ""
        domain: Main
        top_signame: otp_ctrl_sram_otp_key
        index: 4
      }
      {
        name: corei_tl_h
        struct: tl
        package: tlul_pkg
        type: req_rsp
        act: req
        width: 1
        inst_name: rv_core_ibex
        default: ""
        domain: Main
        top_signame: main_tl_rv_core_ibex__corei
        index: -1
      }
      {
        name: cfg_tl_d
        struct: tl
        package: tlul_pkg
        type: req_rsp
        act: rsp
        width: 1
        inst_name: rv_core_ibex
        default: ""
        end_idx: -1
        top_type: one-to-one
        top_signame: rv_core_ibex_cfg_tl_d
        index: -1
      }
      {
        name: cheriot_ena
        desc: CHERIoT mode enable.
        struct: mubi4
        package: prim_mubi_pkg
        type: uni
        act: rcv
        width: 1
        default: prim_mubi_pkg::MuBi4False
        inst_name: cheriot_mem_sys
        domain: Main
        top_signame: rv_core_ibex_cheriot_ena
        index: -1
      }
      {
        name: cored_tl_d
        desc: Data port from the core.
        struct: tl
        package: tlul_pkg
        type: req_rsp
        act: rsp
        width: 1
        inst_name: cheriot_mem_sys
        default: ""
        domain: Main
        top_signame: rv_core_ibex_cored_tl_h
        index: -1
      }
      {
        name: cored_tag_h2d
        desc: CHERIoT capability tag carried with the A-channel of cored_tl_h.
        struct: logic
        type: uni
        act: rcv
        width: 1
        default: 1'b0
        inst_name: cheriot_mem_sys
        package: ""
        domain: Main
        top_signame: rv_core_ibex_cored_tag_h2d
        index: -1
      }
      {
        name: cored_tag_d2h
        desc: Capability tag returned on the D-channel of cored_tl_h.
        struct: logic
        type: uni
        act: req
        width: 1
        default: 1'b0
        inst_name: cheriot_mem_sys
        package: ""
        end_idx: -1
        top_type: broadcast
        top_signame: cheriot_mem_sys_cored_tag_d2h
        index: -1
      }
      {
        name: corerevbm_tl
        desc: TRVK (tag revocation) revocation bitmap port from the core.
        struct: tl
        package: tlul_pkg
        type: req_rsp
        act: rsp
        width: 1
        inst_name: cheriot_mem_sys
        default: ""
        domain: Main
        top_signame: rv_core_ibex_corerevbm_tl
        index: -1
      }
      {
        name: meta_sram_tl
        desc: Host TL-UL port to the external meta SRAM controller's RAM interface.
        struct: tl
        package: tlul_pkg
        type: req_rsp
        act: req
        width: 1
        inst_name: cheriot_mem_sys
        default: ""
        end_idx: -1
        top_type: one-to-one
        top_signame: cheriot_mem_sys_meta_sram_tl
        index: -1
      }
      {
        name: cored_tl_h
        struct: tl
        package: tlul_pkg
        type: req_rsp
        act: req
        width: 1
        inst_name: cheriot_mem_sys
        default: ""
        domain: Main
        top_signame: main_tl_cheriot_mem_sys__cored
        index: -1
      }
      {
        name: tbre_tl_h
        struct: tl
        package: tlul_pkg
        type: req_rsp
        act: req
        width: 1
        inst_name: cheriot_mem_sys
        default: ""
        domain: Main
        top_signame: main_tl_cheriot_mem_sys__tbre
        index: -1
      }
      {
        name: regs_tl_d
        struct: tl
        package: tlul_pkg
        type: req_rsp
        act: rsp
        width: 1
        inst_name: cheriot_mem_sys
        default: ""
        end_idx: -1
        top_type: one-to-one
        top_signame: cheriot_mem_sys_regs_tl_d
        index: -1
      }
      {
        name: revbm_tl_d
        struct: tl
        package: tlul_pkg
        type: req_rsp
        act: rsp
        width: 1
        inst_name: cheriot_mem_sys
        default: ""
        end_idx: -1
        top_type: one-to-one
        top_signame: cheriot_mem_sys_revbm_tl_d
        index: -1
      }
      {
        name: sram_otp_key
        struct: sram_otp_key
        package: otp_ctrl_pkg
        type: req_rsp
        act: req
        width: 1
        inst_name: sram_ctrl_meta
        default: ""
        domain: Main
        top_signame: otp_ctrl_sram_otp_key
        index: 3
      }
      {
        name: ram_cfg
        struct: ram_1p_cfg
        package: prim_ram_1p_pkg
        type: req_rsp
        act: rsp
        width:
        {
          name: NumRamInst
          desc: Number of internal RAM instances. Must be the same as ceil(MemSizeRam / InstSize) .
          param_type: int
          unpacked_dimensions: null
          default: 1
          local: false
          expose: true
          name_top: SramCtrlMetaNumRamInst
        }
        inst_name: sram_ctrl_meta
        default: ""
        top_signame: sram_ctrl_meta_ram_cfg
        index: -1
      }
      {
        name: lc_escalate_en
        struct: lc_tx
        package: lc_ctrl_pkg
        type: uni
        act: rcv
        width: 1
        default: lc_ctrl_pkg::Off
        inst_name: sram_ctrl_meta
        domain: Main
        top_signame: lc_ctrl_lc_escalate_en
        index: -1
      }
      {
        name: lc_hw_debug_en
        struct: lc_tx
        package: lc_ctrl_pkg
        type: uni
        act: rcv
        width: 1
        default: lc_ctrl_pkg::Off
        inst_name: sram_ctrl_meta
        domain: Main
        top_signame: lc_ctrl_lc_hw_debug_en
        index: -1
      }
      {
        name: otp_en_sram_ifetch
        struct: mubi8
        package: prim_mubi_pkg
        type: uni
        act: rcv
        width: 1
        default: prim_mubi_pkg::MuBi8False
        inst_name: sram_ctrl_meta
        index: -1
      }
      {
        name: racl_policies
        desc:
          '''
          Incoming RACL policy vector from a racl_ctrl instance.
          The policy selection vector (parameter) selects the policy for each register.
          '''
        struct: racl_policy_vec
        package: top_racl_pkg
        type: uni
        act: rcv
        width: 1
        inst_name: sram_ctrl_meta
        index: -1
      }
      {
        name: racl_error
        desc: RACL error log information of this module.
        struct: racl_error_log
        package: top_racl_pkg
        type: uni
        act: req
        width: 1
        inst_name: sram_ctrl_meta
        index: -1
      }
      {
        name: sram_rerror
        desc: SRAM read error indicating correctable and uncorrectable ECC errors.
        struct: sram_error_t
        package: sram_ctrl_pkg
        type: uni
        act: req
        width: 1
        inst_name: sram_ctrl_meta
        index: -1
      }
      {
        name: regs_tl
        struct: tl
        package: tlul_pkg
        type: req_rsp
        act: rsp
        width: 1
        inst_name: sram_ctrl_meta
        default: ""
        end_idx: -1
        top_type: one-to-one
        top_signame: sram_ctrl_meta_regs_tl
        index: -1
      }
      {
        name: ram_tl
        struct: tl
        package: tlul_pkg
        type: req_rsp
        act: rsp
        width: 1
        inst_name: sram_ctrl_meta
        default: ""
        domain: Main
        top_signame: cheriot_mem_sys_meta_sram_tl
        index: -1
      }
      {
        name: tl_rv_core_ibex__corei
        struct: tl
        package: tlul_pkg
        type: req_rsp
        act: rsp
        inst_name: main
        width: 1
        default: ""
        end_idx: -1
        top_type: one-to-one
        top_signame: main_tl_rv_core_ibex__corei
        index: -1
      }
      {
        name: tl_cheriot_mem_sys__cored
        struct: tl
        package: tlul_pkg
        type: req_rsp
        act: rsp
        inst_name: main
        width: 1
        default: ""
        end_idx: -1
        top_type: one-to-one
        top_signame: main_tl_cheriot_mem_sys__cored
        index: -1
      }
      {
        name: tl_cheriot_mem_sys__tbre
        struct: tl
        package: tlul_pkg
        type: req_rsp
        act: rsp
        inst_name: main
        width: 1
        default: ""
        end_idx: -1
        top_type: one-to-one
        top_signame: main_tl_cheriot_mem_sys__tbre
        index: -1
      }
      {
        name: tl_rv_dm__sba
        struct: tl
        package: tlul_pkg
        type: req_rsp
        act: rsp
        inst_name: main
        width: 1
        default: ""
        end_idx: -1
        top_type: one-to-one
        top_signame: main_tl_rv_dm__sba
        index: -1
      }
      {
        name: tl_rv_dm__regs
        struct: tl
        package: tlul_pkg
        type: req_rsp
        act: req
        inst_name: main
        width: 1
        default: ""
        domain: Main
        top_signame: rv_dm_regs_tl_d
        index: -1
      }
      {
        name: tl_rv_dm__mem
        struct: tl
        package: tlul_pkg
        type: req_rsp
        act: req
        inst_name: main
        width: 1
        default: ""
        domain: Main
        top_signame: rv_dm_mem_tl_d
        index: -1
      }
      {
        name: tl_rom_ctrl__rom
        struct: tl
        package: tlul_pkg
        type: req_rsp
        act: req
        inst_name: main
        width: 1
        default: ""
        domain: Main
        top_signame: rom_ctrl_rom_tl
        index: -1
      }
      {
        name: tl_rom_ctrl__regs
        struct: tl
        package: tlul_pkg
        type: req_rsp
        act: req
        inst_name: main
        width: 1
        default: ""
        domain: Main
        top_signame: rom_ctrl_regs_tl
        index: -1
      }
      {
        name: tl_peri
        struct: tl
        package: tlul_pkg
        type: req_rsp
        act: req
        inst_name: main
        width: 1
        default: ""
        end_idx: -1
        top_type: one-to-one
        top_signame: main_tl_peri
        index: -1
      }
      {
        name: tl_spi_host0
        struct: tl
        package: tlul_pkg
        type: req_rsp
        act: req
        inst_name: main
        width: 1
        default: ""
        domain: Main
        top_signame: spi_host0_tl
        index: -1
      }
      {
        name: tl_spi_host1
        struct: tl
        package: tlul_pkg
        type: req_rsp
        act: req
        inst_name: main
        width: 1
        default: ""
        domain: Main
        top_signame: spi_host1_tl
        index: -1
      }
      {
        name: tl_i3c0
        struct: tl
        package: tlul_pkg
        type: req_rsp
        act: req
        inst_name: main
        width: 1
        default: ""
        domain: Main
        top_signame: i3c0_tl
        index: -1
      }
      {
        name: tl_i3c1
        struct: tl
        package: tlul_pkg
        type: req_rsp
        act: req
        inst_name: main
        width: 1
        default: ""
        domain: Main
        top_signame: i3c1_tl
        index: -1
      }
      {
        name: tl_usbdev
        struct: tl
        package: tlul_pkg
        type: req_rsp
        act: req
        inst_name: main
        width: 1
        default: ""
        domain: Main
        top_signame: usbdev_tl
        index: -1
      }
      {
        name: tl_rram_ctrl__core
        struct: tl
        package: tlul_pkg
        type: req_rsp
        act: req
        inst_name: main
        width: 1
        default: ""
        domain: Main
        top_signame: rram_ctrl_core_tl
        index: -1
      }
      {
        name: tl_rram_macro__prim
        struct: tl
        package: tlul_pkg
        type: req_rsp
        act: req
        inst_name: main
        width: 1
        default: ""
        domain: Main
        top_signame: rram_macro_prim_tl
        index: -1
      }
      {
        name: tl_rram_ctrl__host
        struct: tl
        package: tlul_pkg
        type: req_rsp
        act: req
        inst_name: main
        width: 1
        default: ""
        domain: Main
        top_signame: rram_ctrl_host_tl
        index: -1
      }
      {
        name: tl_hmac
        struct: tl
        package: tlul_pkg
        type: req_rsp
        act: req
        inst_name: main
        width: 1
        default: ""
        domain: Main
        top_signame: hmac_tl
        index: -1
      }
      {
        name: tl_kmac
        struct: tl
        package: tlul_pkg
        type: req_rsp
        act: req
        inst_name: main
        width: 1
        default: ""
        domain: Main
        top_signame: kmac_tl
        index: -1
      }
      {
        name: tl_aes
        struct: tl
        package: tlul_pkg
        type: req_rsp
        act: req
        inst_name: main
        width: 1
        default: ""
        domain: Main
        top_signame: aes_tl
        index: -1
      }
      {
        name: tl_entropy_src
        struct: tl
        package: tlul_pkg
        type: req_rsp
        act: req
        inst_name: main
        width: 1
        default: ""
        domain: Main
        top_signame: entropy_src_tl
        index: -1
      }
      {
        name: tl_csrng
        struct: tl
        package: tlul_pkg
        type: req_rsp
        act: req
        inst_name: main
        width: 1
        default: ""
        domain: Main
        top_signame: csrng_tl
        index: -1
      }
      {
        name: tl_edn0
        struct: tl
        package: tlul_pkg
        type: req_rsp
        act: req
        inst_name: main
        width: 1
        default: ""
        domain: Main
        top_signame: edn0_tl
        index: -1
      }
      {
        name: tl_edn1
        struct: tl
        package: tlul_pkg
        type: req_rsp
        act: req
        inst_name: main
        width: 1
        default: ""
        domain: Main
        top_signame: edn1_tl
        index: -1
      }
      {
        name: tl_rv_plic
        struct: tl
        package: tlul_pkg
        type: req_rsp
        act: req
        inst_name: main
        width: 1
        default: ""
        domain: Main
        top_signame: rv_plic_tl
        index: -1
      }
      {
        name: tl_otbn
        struct: tl
        package: tlul_pkg
        type: req_rsp
        act: req
        inst_name: main
        width: 1
        default: ""
        domain: Main
        top_signame: otbn_tl
        index: -1
      }
      {
        name: tl_keymgr_dpe
        struct: tl
        package: tlul_pkg
        type: req_rsp
        act: req
        inst_name: main
        width: 1
        default: ""
        domain: Main
        top_signame: keymgr_dpe_tl
        index: -1
      }
      {
        name: tl_rv_core_ibex__cfg
        struct: tl
        package: tlul_pkg
        type: req_rsp
        act: req
        inst_name: main
        width: 1
        default: ""
        domain: Main
        top_signame: rv_core_ibex_cfg_tl_d
        index: -1
      }
      {
        name: tl_sram_ctrl_main__regs
        struct: tl
        package: tlul_pkg
        type: req_rsp
        act: req
        inst_name: main
        width: 1
        default: ""
        domain: Main
        top_signame: sram_ctrl_main_regs_tl
        index: -1
      }
      {
        name: tl_sram_ctrl_main__ram
        struct: tl
        package: tlul_pkg
        type: req_rsp
        act: req
        inst_name: main
        width: 1
        default: ""
        domain: Main
        top_signame: sram_ctrl_main_ram_tl
        index: -1
      }
      {
        name: tl_sram_ctrl_sec__regs
        struct: tl
        package: tlul_pkg
        type: req_rsp
        act: req
        inst_name: main
        width: 1
        default: ""
        domain: Main
        top_signame: sram_ctrl_sec_regs_tl
        index: -1
      }
      {
        name: tl_sram_ctrl_meta__regs
        struct: tl
        package: tlul_pkg
        type: req_rsp
        act: req
        inst_name: main
        width: 1
        default: ""
        domain: Main
        top_signame: sram_ctrl_meta_regs_tl
        index: -1
      }
      {
        name: tl_sram_ctrl_sec__ram
        struct: tl
        package: tlul_pkg
        type: req_rsp
        act: req
        inst_name: main
        width: 1
        default: ""
        domain: Main
        top_signame: sram_ctrl_sec_ram_tl
        index: -1
      }
      {
        name: tl_cheriot_mem_sys__regs
        struct: tl
        package: tlul_pkg
        type: req_rsp
        act: req
        inst_name: main
        width: 1
        default: ""
        domain: Main
        top_signame: cheriot_mem_sys_regs_tl_d
        index: -1
      }
      {
        name: tl_cheriot_mem_sys__revbm
        struct: tl
        package: tlul_pkg
        type: req_rsp
        act: req
        inst_name: main
        width: 1
        default: ""
        domain: Main
        top_signame: cheriot_mem_sys_revbm_tl_d
        index: -1
      }
      {
        name: tl_main
        struct: tl
        package: tlul_pkg
        type: req_rsp
        act: rsp
        inst_name: peri
        width: 1
        default: ""
        domain: Main
        top_signame: main_tl_peri
        index: -1
      }
      {
        name: tl_uart0
        struct: tl
        package: tlul_pkg
        type: req_rsp
        act: req
        inst_name: peri
        width: 1
        default: ""
        domain: Main
        top_signame: uart0_tl
        index: -1
      }
      {
        name: tl_uart1
        struct: tl
        package: tlul_pkg
        type: req_rsp
        act: req
        inst_name: peri
        width: 1
        default: ""
        domain: Main
        top_signame: uart1_tl
        index: -1
      }
      {
        name: tl_uart2
        struct: tl
        package: tlul_pkg
        type: req_rsp
        act: req
        inst_name: peri
        width: 1
        default: ""
        domain: Main
        top_signame: uart2_tl
        index: -1
      }
      {
        name: tl_uart3
        struct: tl
        package: tlul_pkg
        type: req_rsp
        act: req
        inst_name: peri
        width: 1
        default: ""
        domain: Main
        top_signame: uart3_tl
        index: -1
      }
      {
        name: tl_i2c0
        struct: tl
        package: tlul_pkg
        type: req_rsp
        act: req
        inst_name: peri
        width: 1
        default: ""
        domain: Main
        top_signame: i2c0_tl
        index: -1
      }
      {
        name: tl_i2c1
        struct: tl
        package: tlul_pkg
        type: req_rsp
        act: req
        inst_name: peri
        width: 1
        default: ""
        domain: Main
        top_signame: i2c1_tl
        index: -1
      }
      {
        name: tl_i2c2
        struct: tl
        package: tlul_pkg
        type: req_rsp
        act: req
        inst_name: peri
        width: 1
        default: ""
        domain: Main
        top_signame: i2c2_tl
        index: -1
      }
      {
        name: tl_gpio0
        struct: tl
        package: tlul_pkg
        type: req_rsp
        act: req
        inst_name: peri
        width: 1
        default: ""
        domain: Main
        top_signame: gpio0_tl
        index: -1
      }
      {
        name: tl_gpio1
        struct: tl
        package: tlul_pkg
        type: req_rsp
        act: req
        inst_name: peri
        width: 1
        default: ""
        domain: Main
        top_signame: gpio1_tl
        index: -1
      }
      {
        name: tl_spi_device
        struct: tl
        package: tlul_pkg
        type: req_rsp
        act: req
        inst_name: peri
        width: 1
        default: ""
        domain: Main
        top_signame: spi_device_tl
        index: -1
      }
      {
        name: tl_rv_timer
        struct: tl
        package: tlul_pkg
        type: req_rsp
        act: req
        inst_name: peri
        width: 1
        default: ""
        domain: Main
        top_signame: rv_timer_tl
        index: -1
      }
      {
        name: tl_pwrmgr
        struct: tl
        package: tlul_pkg
        type: req_rsp
        act: req
        inst_name: peri
        width: 1
        default: ""
        domain: Main
        top_signame: pwrmgr_tl
        index: -1
        external: true
        conn_type: false
      }
      {
        name: tl_rstmgr
        struct: tl
        package: tlul_pkg
        type: req_rsp
        act: req
        inst_name: peri
        width: 1
        default: ""
        domain: Main
        top_signame: rstmgr_tl
        index: -1
        external: true
        conn_type: false
      }
      {
        name: tl_clkmgr
        struct: tl
        package: tlul_pkg
        type: req_rsp
        act: req
        inst_name: peri
        width: 1
        default: ""
        domain: Main
        top_signame: clkmgr_tl
        index: -1
        external: true
        conn_type: false
      }
      {
        name: tl_pinmux
        struct: tl
        package: tlul_pkg
        type: req_rsp
        act: req
        inst_name: peri
        width: 1
        default: ""
        domain: Main
        top_signame: pinmux_tl
        index: -1
        external: true
        conn_type: false
      }
      {
        name: tl_otp_ctrl__core
        struct: tl
        package: tlul_pkg
        type: req_rsp
        act: req
        inst_name: peri
        width: 1
        default: ""
        domain: Main
        top_signame: otp_ctrl_core_tl
        index: -1
      }
      {
        name: tl_lc_ctrl__regs
        struct: tl
        package: tlul_pkg
        type: req_rsp
        act: req
        inst_name: peri
        width: 1
        default: ""
        domain: Main
        top_signame: lc_ctrl_regs_tl
        index: -1
      }
      {
        name: tl_sensor_ctrl
        struct: tl
        package: tlul_pkg
        type: req_rsp
        act: req
        inst_name: peri
        width: 1
        default: ""
        domain: Main
        top_signame: sensor_ctrl_tl
        index: -1
        external: true
        conn_type: false
      }
      {
        name: tl_alert_handler
        struct: tl
        package: tlul_pkg
        type: req_rsp
        act: req
        inst_name: peri
        width: 1
        default: ""
        domain: Main
        top_signame: alert_handler_tl
        index: -1
      }
      {
        name: tl_sram_ctrl_ret__regs
        struct: tl
        package: tlul_pkg
        type: req_rsp
        act: req
        inst_name: peri
        width: 1
        default: ""
        domain: Main
        top_signame: sram_ctrl_ret_regs_tl
        index: -1
        external: true
        conn_type: false
      }
      {
        name: tl_sram_ctrl_ret__ram
        struct: tl
        package: tlul_pkg
        type: req_rsp
        act: req
        inst_name: peri
        width: 1
        default: ""
        domain: Main
        top_signame: sram_ctrl_ret_ram_tl
        index: -1
        external: true
        conn_type: false
      }
      {
        name: tl_aon_timer
        struct: tl
        package: tlul_pkg
        type: req_rsp
        act: req
        inst_name: peri
        width: 1
        default: ""
        domain: Main
        top_signame: aon_timer_tl
        index: -1
        external: true
        conn_type: false
      }
      {
        name: tl_sysrst_ctrl
        struct: tl
        package: tlul_pkg
        type: req_rsp
        act: req
        inst_name: peri
        width: 1
        default: ""
        domain: Main
        top_signame: sysrst_ctrl_tl
        index: -1
        external: true
        conn_type: false
      }
      {
        name: tl_adc_ctrl
        struct: tl
        package: tlul_pkg
        type: req_rsp
        act: req
        inst_name: peri
        width: 1
        default: ""
        domain: Main
        top_signame: adc_ctrl_tl
        index: -1
        external: true
        conn_type: false
      }
      {
        name: tl_ast
        struct: tl
        package: tlul_pkg
        type: req_rsp
        act: req
        inst_name: peri
        width: 1
        default: ""
        domain: Main
        top_signame: ast_tl
        index: -1
      }
    ]
    external:
    [
      {
        package: ast_pkg
        struct: ast_obs_ctrl
        domain: Aon
        inter_pd: true
        signame: ast_obs_ctrl_o
        signame_chip:
        {
          asic: ast_obs_ctrl
          verilator: ast_obs_ctrl
          cw340: ast_obs_ctrl
        }
        width: 1
        type: uni
        default: ""
        direction: out
        conn_type: false
        index: -1
        netname: ast_obs_ctrl
      }
      {
        package: ast_pkg
        struct: ast_obs_ctrl
        domain: Main
        inter_pd: true
        signame: ast_obs_ctrl_i
        signame_chip:
        {
          asic: ast_obs_ctrl
          verilator: ast_obs_ctrl
          cw340: ast_obs_ctrl
        }
        width: 1
        type: uni
        default: ""
        direction: in
        conn_type: false
        index: -1
        netname: ast_obs_ctrl
      }
      {
        package: prim_mubi_pkg
        struct: mubi4
        domain: Main
        inter_pd: true
        signame: ast_clk_src_sys_jen_i
        signame_chip:
        {
          asic: ast_clk_src_sys_jen
          verilator: ast_clk_src_sys_jen
          cw340: ast_clk_src_sys_jen
        }
        width: 1
        type: uni
        default: ""
        direction: in
        conn_type: false
        index: -1
        netname: ast_clk_src_sys_jen
      }
      {
        package: prim_mubi_pkg
        struct: mubi4
        domain: Aon
        inter_pd: true
        signame: ast_clk_src_sys_jen_o
        signame_chip:
        {
          asic: ast_clk_src_sys_jen
          verilator: ast_clk_src_sys_jen
          cw340: ast_clk_src_sys_jen
        }
        width: 1
        type: uni
        default: ""
        direction: out
        conn_type: false
        index: -1
        netname: ast_clk_src_sys_jen
      }
      {
        package: prim_mubi_pkg
        struct: mubi4
        domain: Main
        inter_pd: true
        signame: ast_init_done_o
        signame_chip:
        {
          asic: ast_init_done
          verilator: ast_init_done
          cw340: ast_init_done
        }
        width: 1
        type: uni
        default: ""
        direction: out
        conn_type: false
        index: -1
        netname: ast_init_done
      }
      {
        package: prim_mubi_pkg
        struct: mubi4
        domain: Aon
        inter_pd: true
        signame: ast_init_done_i
        signame_chip:
        {
          asic: ast_init_done
          verilator: ast_init_done
          cw340: ast_init_done
        }
        width: 1
        type: uni
        default: ""
        direction: in
        conn_type: false
        index: -1
        netname: ast_init_done
      }
      {
        package: prim_mubi_pkg
        struct: mubi4
        domain: Aon
        inter_pd: true
        signame: clkmgr_all_clk_byp_req_o
        signame_chip:
        {
          asic: clkmgr_all_clk_byp_req
          verilator: clkmgr_all_clk_byp_req
          cw340: clkmgr_all_clk_byp_req
        }
        width: 1
        type: uni
        default: ""
        direction: out
        conn_type: false
        index: -1
        netname: clkmgr_all_clk_byp_req
      }
      {
        package: prim_mubi_pkg
        struct: mubi4
        domain: Main
        inter_pd: true
        signame: clkmgr_all_clk_byp_req_i
        signame_chip:
        {
          asic: clkmgr_all_clk_byp_req
          verilator: clkmgr_all_clk_byp_req
          cw340: clkmgr_all_clk_byp_req
        }
        width: 1
        type: uni
        default: ""
        direction: in
        conn_type: false
        index: -1
        netname: clkmgr_all_clk_byp_req
      }
      {
        package: prim_mubi_pkg
        struct: mubi4
        domain: Aon
        inter_pd: true
        signame: clkmgr_all_clk_byp_ack_i
        signame_chip:
        {
          asic: clkmgr_all_clk_byp_ack
          verilator: clkmgr_all_clk_byp_ack
          cw340: clkmgr_all_clk_byp_ack
        }
        width: 1
        type: uni
        default: ""
        direction: in
        conn_type: false
        index: -1
        netname: clkmgr_all_clk_byp_ack
      }
      {
        package: prim_mubi_pkg
        struct: mubi4
        domain: Main
        inter_pd: true
        signame: clkmgr_all_clk_byp_ack_o
        signame_chip:
        {
          asic: clkmgr_all_clk_byp_ack
          verilator: clkmgr_all_clk_byp_ack
          cw340: clkmgr_all_clk_byp_ack
        }
        width: 1
        type: uni
        default: ""
        direction: out
        conn_type: false
        index: -1
        netname: clkmgr_all_clk_byp_ack
      }
      {
        package: prim_mubi_pkg
        struct: mubi4
        domain: Aon
        inter_pd: true
        signame: clkmgr_io_clk_byp_req_o
        signame_chip:
        {
          asic: clkmgr_io_clk_byp_req
          verilator: clkmgr_io_clk_byp_req
          cw340: clkmgr_io_clk_byp_req
        }
        width: 1
        type: uni
        default: ""
        direction: out
        conn_type: false
        index: -1
        netname: clkmgr_io_clk_byp_req
      }
      {
        package: prim_mubi_pkg
        struct: mubi4
        domain: Main
        inter_pd: true
        signame: clkmgr_io_clk_byp_req_i
        signame_chip:
        {
          asic: clkmgr_io_clk_byp_req
          verilator: clkmgr_io_clk_byp_req
          cw340: clkmgr_io_clk_byp_req
        }
        width: 1
        type: uni
        default: ""
        direction: in
        conn_type: false
        index: -1
        netname: clkmgr_io_clk_byp_req
      }
      {
        package: prim_mubi_pkg
        struct: mubi4
        domain: Aon
        inter_pd: true
        signame: clkmgr_io_clk_byp_ack_i
        signame_chip:
        {
          asic: clkmgr_io_clk_byp_ack
          verilator: clkmgr_io_clk_byp_ack
          cw340: clkmgr_io_clk_byp_ack
        }
        width: 1
        type: uni
        default: ""
        direction: in
        conn_type: false
        index: -1
        netname: clkmgr_io_clk_byp_ack
      }
      {
        package: prim_mubi_pkg
        struct: mubi4
        domain: Main
        inter_pd: true
        signame: clkmgr_io_clk_byp_ack_o
        signame_chip:
        {
          asic: clkmgr_io_clk_byp_ack
          verilator: clkmgr_io_clk_byp_ack
          cw340: clkmgr_io_clk_byp_ack
        }
        width: 1
        type: uni
        default: ""
        direction: out
        conn_type: false
        index: -1
        netname: clkmgr_io_clk_byp_ack
      }
      {
        package: prim_mubi_pkg
        struct: mubi4
        domain: Aon
        inter_pd: true
        signame: clkmgr_hi_speed_sel_o
        signame_chip:
        {
          asic: clkmgr_hi_speed_sel
          verilator: clkmgr_hi_speed_sel
          cw340: clkmgr_hi_speed_sel
        }
        width: 1
        type: uni
        default: ""
        direction: out
        conn_type: false
        index: -1
        netname: clkmgr_hi_speed_sel
      }
      {
        package: prim_mubi_pkg
        struct: mubi4
        domain: Main
        inter_pd: true
        signame: clkmgr_hi_speed_sel_i
        signame_chip:
        {
          asic: clkmgr_hi_speed_sel
          verilator: clkmgr_hi_speed_sel
          cw340: clkmgr_hi_speed_sel
        }
        width: 1
        type: uni
        default: ""
        direction: in
        conn_type: false
        index: -1
        netname: clkmgr_hi_speed_sel
      }
      {
        package: prim_mubi_pkg
        struct: mubi4
        domain: Aon
        inter_pd: true
        signame: clkmgr_div_step_down_req_i
        signame_chip:
        {
          asic: clkmgr_div_step_down_req
          verilator: clkmgr_div_step_down_req
          cw340: clkmgr_div_step_down_req
        }
        width: 1
        type: uni
        default: ""
        direction: in
        conn_type: false
        index: -1
        netname: clkmgr_div_step_down_req
      }
      {
        package: prim_mubi_pkg
        struct: mubi4
        domain: Main
        inter_pd: true
        signame: clkmgr_div_step_down_req_o
        signame_chip:
        {
          asic: clkmgr_div_step_down_req
          verilator: clkmgr_div_step_down_req
          cw340: clkmgr_div_step_down_req
        }
        width: 1
        type: uni
        default: ""
        direction: out
        conn_type: false
        index: -1
        netname: clkmgr_div_step_down_req
      }
      {
        package: alert_handler_pkg
        struct: alert_crashdump
        domain: Main
        inter_pd: true
        signame: alert_handler_crashdump_o
        signame_chip:
        {
          asic: alert_handler_crashdump
          verilator: alert_handler_crashdump
          cw340: alert_handler_crashdump
        }
        width: 1
        type: uni
        default: ""
        direction: out
        conn_type: false
        index: -1
        netname: alert_handler_crashdump
      }
      {
        package: alert_handler_pkg
        struct: alert_crashdump
        domain: Aon
        inter_pd: true
        signame: alert_handler_crashdump_i
        signame_chip:
        {
          asic: alert_handler_crashdump
          verilator: alert_handler_crashdump
          cw340: alert_handler_crashdump
        }
        width: 1
        type: uni
        default: ""
        direction: in
        conn_type: false
        index: -1
        netname: alert_handler_crashdump
      }
      {
        package: prim_esc_pkg
        struct: esc_rx
        domain: Main
        inter_pd: true
        signame: alert_handler_esc_rx_i
        signame_chip:
        {
          asic: alert_handler_esc_rx
          verilator: alert_handler_esc_rx
          cw340: alert_handler_esc_rx
        }
        width: 1
        type: uni
        default: ""
        direction: in
        conn_type: true
        index: 3
        netname: alert_handler_esc_rx
      }
      {
        package: prim_esc_pkg
        struct: esc_rx
        domain: Aon
        inter_pd: true
        signame: alert_handler_esc_rx_o
        signame_chip:
        {
          asic: alert_handler_esc_rx
          verilator: alert_handler_esc_rx
          cw340: alert_handler_esc_rx
        }
        width: 1
        type: uni
        default: ""
        direction: out
        conn_type: false
        index: 3
        netname: alert_handler_esc_rx
      }
      {
        package: prim_esc_pkg
        struct: esc_tx
        domain: Main
        inter_pd: true
        signame: alert_handler_esc_tx_o
        signame_chip:
        {
          asic: alert_handler_esc_tx
          verilator: alert_handler_esc_tx
          cw340: alert_handler_esc_tx
        }
        width: 1
        type: uni
        default: ""
        direction: out
        conn_type: true
        index: 3
        netname: alert_handler_esc_tx
      }
      {
        package: prim_esc_pkg
        struct: esc_tx
        domain: Aon
        inter_pd: true
        signame: alert_handler_esc_tx_i
        signame_chip:
        {
          asic: alert_handler_esc_tx
          verilator: alert_handler_esc_tx
          cw340: alert_handler_esc_tx
        }
        width: 1
        type: uni
        default: ""
        direction: in
        conn_type: false
        index: 3
        netname: alert_handler_esc_tx
      }
      {
        package: ""
        struct: logic
        domain: Aon
        inter_pd: true
        signame: aon_timer_nmi_wdog_timer_bark_o
        signame_chip:
        {
          asic: aon_timer_nmi_wdog_timer_bark
          verilator: aon_timer_nmi_wdog_timer_bark
          cw340: aon_timer_nmi_wdog_timer_bark
        }
        width: 1
        type: uni
        default: 1'b0
        direction: out
        conn_type: false
        index: -1
        netname: aon_timer_nmi_wdog_timer_bark
      }
      {
        package: ""
        struct: logic
        domain: Main
        inter_pd: true
        signame: aon_timer_nmi_wdog_timer_bark_i
        signame_chip:
        {
          asic: aon_timer_nmi_wdog_timer_bark
          verilator: aon_timer_nmi_wdog_timer_bark
          cw340: aon_timer_nmi_wdog_timer_bark
        }
        width: 1
        type: uni
        default: 1'b0
        direction: in
        conn_type: false
        index: -1
        netname: aon_timer_nmi_wdog_timer_bark
      }
      {
        package: otp_ctrl_pkg
        struct: sram_otp_key_req
        domain: Main
        inter_pd: true
        signame: otp_ctrl_sram_otp_key_req_i
        signame_chip:
        {
          asic: otp_ctrl_sram_otp_key_req
          verilator: otp_ctrl_sram_otp_key_req
          cw340: otp_ctrl_sram_otp_key_req
        }
        width: 1
        type: req_rsp
        default: "'0"
        direction: in
        conn_type: true
        index: 2
        netname: otp_ctrl_sram_otp_key_req
      }
      {
        package: otp_ctrl_pkg
        struct: sram_otp_key_rsp
        domain: Main
        inter_pd: true
        signame: otp_ctrl_sram_otp_key_rsp_o
        signame_chip:
        {
          asic: otp_ctrl_sram_otp_key_rsp
          verilator: otp_ctrl_sram_otp_key_rsp
          cw340: otp_ctrl_sram_otp_key_rsp
        }
        width: 1
        type: req_rsp
        default: "'0"
        direction: out
        conn_type: true
        index: 2
        netname: otp_ctrl_sram_otp_key_rsp
      }
      {
        package: otp_ctrl_pkg
        struct: sram_otp_key_req
        domain: Aon
        inter_pd: true
        signame: otp_ctrl_sram_otp_key_req_o
        signame_chip:
        {
          asic: otp_ctrl_sram_otp_key_req
          verilator: otp_ctrl_sram_otp_key_req
          cw340: otp_ctrl_sram_otp_key_req
        }
        width: 1
        type: req_rsp
        default: "'0"
        direction: out
        conn_type: false
        index: 2
        netname: otp_ctrl_sram_otp_key_req
      }
      {
        package: otp_ctrl_pkg
        struct: sram_otp_key_rsp
        domain: Aon
        inter_pd: true
        signame: otp_ctrl_sram_otp_key_rsp_i
        signame_chip:
        {
          asic: otp_ctrl_sram_otp_key_rsp
          verilator: otp_ctrl_sram_otp_key_rsp
          cw340: otp_ctrl_sram_otp_key_rsp
        }
        width: 1
        type: req_rsp
        default: "'0"
        direction: in
        conn_type: false
        index: 2
        netname: otp_ctrl_sram_otp_key_rsp
      }
      {
        package: pwrmgr_pkg
        struct: pwr_nvm
        domain: Aon
        inter_pd: true
        signame: pwrmgr_pwr_nvm_i
        signame_chip:
        {
          asic: pwrmgr_pwr_nvm
          verilator: pwrmgr_pwr_nvm
          cw340: pwrmgr_pwr_nvm
        }
        width: 1
        type: uni
        default: ""
        direction: in
        conn_type: false
        index: -1
        netname: pwrmgr_pwr_nvm
      }
      {
        package: pwrmgr_pkg
        struct: pwr_nvm
        domain: Main
        inter_pd: true
        signame: pwrmgr_pwr_nvm_o
        signame_chip:
        {
          asic: pwrmgr_pwr_nvm
          verilator: pwrmgr_pwr_nvm
          cw340: pwrmgr_pwr_nvm
        }
        width: 1
        type: uni
        default: ""
        direction: out
        conn_type: false
        index: -1
        netname: pwrmgr_pwr_nvm
      }
      {
        package: pwrmgr_pkg
        struct: pwr_otp_req
        domain: Aon
        inter_pd: true
        signame: pwrmgr_pwr_otp_req_o
        signame_chip:
        {
          asic: pwrmgr_pwr_otp_req
          verilator: pwrmgr_pwr_otp_req
          cw340: pwrmgr_pwr_otp_req
        }
        width: 1
        type: req_rsp
        default: ""
        direction: out
        conn_type: false
        index: -1
        netname: pwrmgr_pwr_otp_req
      }
      {
        package: pwrmgr_pkg
        struct: pwr_otp_rsp
        domain: Aon
        inter_pd: true
        signame: pwrmgr_pwr_otp_rsp_i
        signame_chip:
        {
          asic: pwrmgr_pwr_otp_rsp
          verilator: pwrmgr_pwr_otp_rsp
          cw340: pwrmgr_pwr_otp_rsp
        }
        width: 1
        type: req_rsp
        default: ""
        direction: in
        conn_type: false
        index: -1
        netname: pwrmgr_pwr_otp_rsp
      }
      {
        package: pwrmgr_pkg
        struct: pwr_otp_req
        domain: Main
        inter_pd: true
        signame: pwrmgr_pwr_otp_req_i
        signame_chip:
        {
          asic: pwrmgr_pwr_otp_req
          verilator: pwrmgr_pwr_otp_req
          cw340: pwrmgr_pwr_otp_req
        }
        width: 1
        type: req_rsp
        default: ""
        direction: in
        conn_type: false
        index: -1
        netname: pwrmgr_pwr_otp_req
      }
      {
        package: pwrmgr_pkg
        struct: pwr_otp_rsp
        domain: Main
        inter_pd: true
        signame: pwrmgr_pwr_otp_rsp_o
        signame_chip:
        {
          asic: pwrmgr_pwr_otp_rsp
          verilator: pwrmgr_pwr_otp_rsp
          cw340: pwrmgr_pwr_otp_rsp
        }
        width: 1
        type: req_rsp
        default: ""
        direction: out
        conn_type: false
        index: -1
        netname: pwrmgr_pwr_otp_rsp
      }
      {
        package: lc_ctrl_pkg
        struct: pwr_lc_req
        domain: Aon
        inter_pd: true
        signame: pwrmgr_pwr_lc_req_o
        signame_chip:
        {
          asic: pwrmgr_pwr_lc_req
          verilator: pwrmgr_pwr_lc_req
          cw340: pwrmgr_pwr_lc_req
        }
        width: 1
        type: req_rsp
        default: ""
        direction: out
        conn_type: false
        index: -1
        netname: pwrmgr_pwr_lc_req
      }
      {
        package: lc_ctrl_pkg
        struct: pwr_lc_rsp
        domain: Aon
        inter_pd: true
        signame: pwrmgr_pwr_lc_rsp_i
        signame_chip:
        {
          asic: pwrmgr_pwr_lc_rsp
          verilator: pwrmgr_pwr_lc_rsp
          cw340: pwrmgr_pwr_lc_rsp
        }
        width: 1
        type: req_rsp
        default: ""
        direction: in
        conn_type: false
        index: -1
        netname: pwrmgr_pwr_lc_rsp
      }
      {
        package: lc_ctrl_pkg
        struct: pwr_lc_req
        domain: Main
        inter_pd: true
        signame: pwrmgr_pwr_lc_req_i
        signame_chip:
        {
          asic: pwrmgr_pwr_lc_req
          verilator: pwrmgr_pwr_lc_req
          cw340: pwrmgr_pwr_lc_req
        }
        width: 1
        type: req_rsp
        default: ""
        direction: in
        conn_type: false
        index: -1
        netname: pwrmgr_pwr_lc_req
      }
      {
        package: lc_ctrl_pkg
        struct: pwr_lc_rsp
        domain: Main
        inter_pd: true
        signame: pwrmgr_pwr_lc_rsp_o
        signame_chip:
        {
          asic: pwrmgr_pwr_lc_rsp
          verilator: pwrmgr_pwr_lc_rsp
          cw340: pwrmgr_pwr_lc_rsp
        }
        width: 1
        type: req_rsp
        default: ""
        direction: out
        conn_type: false
        index: -1
        netname: pwrmgr_pwr_lc_rsp
      }
      {
        package: lc_ctrl_pkg
        struct: lc_tx
        domain: Aon
        inter_pd: true
        signame: pwrmgr_fetch_en_o
        signame_chip:
        {
          asic: pwrmgr_fetch_en
          verilator: pwrmgr_fetch_en
          cw340: pwrmgr_fetch_en
        }
        width: 1
        type: uni
        default: ""
        direction: out
        conn_type: false
        index: -1
        netname: pwrmgr_fetch_en
      }
      {
        package: lc_ctrl_pkg
        struct: lc_tx
        domain: Main
        inter_pd: true
        signame: pwrmgr_fetch_en_i
        signame_chip:
        {
          asic: pwrmgr_fetch_en
          verilator: pwrmgr_fetch_en
          cw340: pwrmgr_fetch_en
        }
        width: 1
        type: uni
        default: ""
        direction: in
        conn_type: false
        index: -1
        netname: pwrmgr_fetch_en
      }
      {
        package: rom_ctrl_pkg
        struct: pwrmgr_data
        domain: Main
        inter_pd: true
        signame: rom_ctrl_pwrmgr_data_o
        signame_chip:
        {
          asic: rom_ctrl_pwrmgr_data
          verilator: rom_ctrl_pwrmgr_data
          cw340: rom_ctrl_pwrmgr_data
        }
        width: 1
        type: uni
        default: ""
        direction: out
        conn_type: false
        index: -1
        netname: rom_ctrl_pwrmgr_data
      }
      {
        package: rom_ctrl_pkg
        struct: pwrmgr_data
        domain: Aon
        inter_pd: true
        signame: rom_ctrl_pwrmgr_data_i
        signame_chip:
        {
          asic: rom_ctrl_pwrmgr_data
          verilator: rom_ctrl_pwrmgr_data
          cw340: rom_ctrl_pwrmgr_data
        }
        width: 1
        type: uni
        default: ""
        direction: in
        conn_type: false
        index: -1
        netname: rom_ctrl_pwrmgr_data
      }
      {
        package: ""
        struct: logic
        domain: Main
        inter_pd: true
        signame: usbdev_usb_dp_pullup_o
        signame_chip:
        {
          asic: usbdev_usb_dp_pullup
          verilator: usbdev_usb_dp_pullup
          cw340: usbdev_usb_dp_pullup
        }
        width: 1
        type: uni
        default: ""
        direction: out
        conn_type: false
        index: -1
        netname: usbdev_usb_dp_pullup
      }
      {
        package: ""
        struct: logic
        domain: Aon
        inter_pd: true
        signame: usbdev_usb_dp_pullup_i
        signame_chip:
        {
          asic: usbdev_usb_dp_pullup
          verilator: usbdev_usb_dp_pullup
          cw340: usbdev_usb_dp_pullup
        }
        width: 1
        type: uni
        default: ""
        direction: in
        conn_type: false
        index: -1
        netname: usbdev_usb_dp_pullup
      }
      {
        package: ""
        struct: logic
        domain: Main
        inter_pd: true
        signame: usbdev_usb_dn_pullup_o
        signame_chip:
        {
          asic: usbdev_usb_dn_pullup
          verilator: usbdev_usb_dn_pullup
          cw340: usbdev_usb_dn_pullup
        }
        width: 1
        type: uni
        default: ""
        direction: out
        conn_type: false
        index: -1
        netname: usbdev_usb_dn_pullup
      }
      {
        package: ""
        struct: logic
        domain: Aon
        inter_pd: true
        signame: usbdev_usb_dn_pullup_i
        signame_chip:
        {
          asic: usbdev_usb_dn_pullup
          verilator: usbdev_usb_dn_pullup
          cw340: usbdev_usb_dn_pullup
        }
        width: 1
        type: uni
        default: ""
        direction: in
        conn_type: false
        index: -1
        netname: usbdev_usb_dn_pullup
      }
      {
        package: ""
        struct: logic
        domain: Main
        inter_pd: true
        signame: usbdev_usb_aon_suspend_req_o
        signame_chip:
        {
          asic: usbdev_usb_aon_suspend_req
          verilator: usbdev_usb_aon_suspend_req
          cw340: usbdev_usb_aon_suspend_req
        }
        width: 1
        type: uni
        default: ""
        direction: out
        conn_type: false
        index: -1
        netname: usbdev_usb_aon_suspend_req
      }
      {
        package: ""
        struct: logic
        domain: Aon
        inter_pd: true
        signame: usbdev_usb_aon_suspend_req_i
        signame_chip:
        {
          asic: usbdev_usb_aon_suspend_req
          verilator: usbdev_usb_aon_suspend_req
          cw340: usbdev_usb_aon_suspend_req
        }
        width: 1
        type: uni
        default: ""
        direction: in
        conn_type: false
        index: -1
        netname: usbdev_usb_aon_suspend_req
      }
      {
        package: ""
        struct: logic
        domain: Main
        inter_pd: true
        signame: usbdev_usb_aon_wake_ack_o
        signame_chip:
        {
          asic: usbdev_usb_aon_wake_ack
          verilator: usbdev_usb_aon_wake_ack
          cw340: usbdev_usb_aon_wake_ack
        }
        width: 1
        type: uni
        default: ""
        direction: out
        conn_type: false
        index: -1
        netname: usbdev_usb_aon_wake_ack
      }
      {
        package: ""
        struct: logic
        domain: Aon
        inter_pd: true
        signame: usbdev_usb_aon_wake_ack_i
        signame_chip:
        {
          asic: usbdev_usb_aon_wake_ack
          verilator: usbdev_usb_aon_wake_ack
          cw340: usbdev_usb_aon_wake_ack
        }
        width: 1
        type: uni
        default: ""
        direction: in
        conn_type: false
        index: -1
        netname: usbdev_usb_aon_wake_ack
      }
      {
        package: ""
        struct: logic
        domain: Main
        inter_pd: true
        signame: usbdev_usb_aon_bus_not_idle_i
        signame_chip:
        {
          asic: usbdev_usb_aon_bus_not_idle
          verilator: usbdev_usb_aon_bus_not_idle
          cw340: usbdev_usb_aon_bus_not_idle
        }
        width: 1
        type: uni
        default: ""
        direction: in
        conn_type: false
        index: -1
        netname: usbdev_usb_aon_bus_not_idle
      }
      {
        package: ""
        struct: logic
        domain: Aon
        inter_pd: true
        signame: usbdev_usb_aon_bus_not_idle_o
        signame_chip:
        {
          asic: usbdev_usb_aon_bus_not_idle
          verilator: usbdev_usb_aon_bus_not_idle
          cw340: usbdev_usb_aon_bus_not_idle
        }
        width: 1
        type: uni
        default: ""
        direction: out
        conn_type: false
        index: -1
        netname: usbdev_usb_aon_bus_not_idle
      }
      {
        package: ""
        struct: logic
        domain: Main
        inter_pd: true
        signame: usbdev_usb_aon_bus_reset_i
        signame_chip:
        {
          asic: usbdev_usb_aon_bus_reset
          verilator: usbdev_usb_aon_bus_reset
          cw340: usbdev_usb_aon_bus_reset
        }
        width: 1
        type: uni
        default: ""
        direction: in
        conn_type: false
        index: -1
        netname: usbdev_usb_aon_bus_reset
      }
      {
        package: ""
        struct: logic
        domain: Aon
        inter_pd: true
        signame: usbdev_usb_aon_bus_reset_o
        signame_chip:
        {
          asic: usbdev_usb_aon_bus_reset
          verilator: usbdev_usb_aon_bus_reset
          cw340: usbdev_usb_aon_bus_reset
        }
        width: 1
        type: uni
        default: ""
        direction: out
        conn_type: false
        index: -1
        netname: usbdev_usb_aon_bus_reset
      }
      {
        package: ""
        struct: logic
        domain: Main
        inter_pd: true
        signame: usbdev_usb_aon_sense_lost_i
        signame_chip:
        {
          asic: usbdev_usb_aon_sense_lost
          verilator: usbdev_usb_aon_sense_lost
          cw340: usbdev_usb_aon_sense_lost
        }
        width: 1
        type: uni
        default: ""
        direction: in
        conn_type: false
        index: -1
        netname: usbdev_usb_aon_sense_lost
      }
      {
        package: ""
        struct: logic
        domain: Aon
        inter_pd: true
        signame: usbdev_usb_aon_sense_lost_o
        signame_chip:
        {
          asic: usbdev_usb_aon_sense_lost
          verilator: usbdev_usb_aon_sense_lost
          cw340: usbdev_usb_aon_sense_lost
        }
        width: 1
        type: uni
        default: ""
        direction: out
        conn_type: false
        index: -1
        netname: usbdev_usb_aon_sense_lost
      }
      {
        package: ""
        struct: logic
        domain: Aon
        inter_pd: true
        signame: pinmux_usbdev_wake_detect_active_o
        signame_chip:
        {
          asic: pinmux_usbdev_wake_detect_active
          verilator: pinmux_usbdev_wake_detect_active
          cw340: pinmux_usbdev_wake_detect_active
        }
        width: 1
        type: uni
        default: 1'b0
        direction: out
        conn_type: false
        index: -1
        netname: pinmux_usbdev_wake_detect_active
      }
      {
        package: ""
        struct: logic
        domain: Main
        inter_pd: true
        signame: pinmux_usbdev_wake_detect_active_i
        signame_chip:
        {
          asic: pinmux_usbdev_wake_detect_active
          verilator: pinmux_usbdev_wake_detect_active
          cw340: pinmux_usbdev_wake_detect_active
        }
        width: 1
        type: uni
        default: 1'b0
        direction: in
        conn_type: false
        index: -1
        netname: pinmux_usbdev_wake_detect_active
      }
      {
        package: prim_mubi_pkg
        struct: mubi4
        domain: Aon
        inter_pd: true
        signame: clkmgr_idle_i
        signame_chip:
        {
          asic: clkmgr_idle
          verilator: clkmgr_idle
          cw340: clkmgr_idle
        }
        width: 4
        type: uni
        default: ""
        direction: in
        conn_type: false
        index: -1
        netname: clkmgr_idle
      }
      {
        package: prim_mubi_pkg
        struct: mubi4
        domain: Main
        inter_pd: true
        signame: clkmgr_idle_o
        signame_chip:
        {
          asic: clkmgr_idle
          verilator: clkmgr_idle
          cw340: clkmgr_idle
        }
        width: 4
        type: uni
        default: ""
        direction: out
        conn_type: false
        index: -1
        netname: clkmgr_idle
      }
      {
        package: jtag_pkg
        struct: jtag_req
        domain: Aon
        inter_pd: true
        signame: pinmux_lc_jtag_req_o
        signame_chip:
        {
          asic: pinmux_lc_jtag_req
          verilator: pinmux_lc_jtag_req
          cw340: pinmux_lc_jtag_req
        }
        width: 1
        type: req_rsp
        default: ""
        direction: out
        conn_type: false
        index: -1
        netname: pinmux_lc_jtag_req
      }
      {
        package: jtag_pkg
        struct: jtag_rsp
        domain: Aon
        inter_pd: true
        signame: pinmux_lc_jtag_rsp_i
        signame_chip:
        {
          asic: pinmux_lc_jtag_rsp
          verilator: pinmux_lc_jtag_rsp
          cw340: pinmux_lc_jtag_rsp
        }
        width: 1
        type: req_rsp
        default: ""
        direction: in
        conn_type: false
        index: -1
        netname: pinmux_lc_jtag_rsp
      }
      {
        package: jtag_pkg
        struct: jtag_req
        domain: Main
        inter_pd: true
        signame: pinmux_lc_jtag_req_i
        signame_chip:
        {
          asic: pinmux_lc_jtag_req
          verilator: pinmux_lc_jtag_req
          cw340: pinmux_lc_jtag_req
        }
        width: 1
        type: req_rsp
        default: ""
        direction: in
        conn_type: false
        index: -1
        netname: pinmux_lc_jtag_req
      }
      {
        package: jtag_pkg
        struct: jtag_rsp
        domain: Main
        inter_pd: true
        signame: pinmux_lc_jtag_rsp_o
        signame_chip:
        {
          asic: pinmux_lc_jtag_rsp
          verilator: pinmux_lc_jtag_rsp
          cw340: pinmux_lc_jtag_rsp
        }
        width: 1
        type: req_rsp
        default: ""
        direction: out
        conn_type: false
        index: -1
        netname: pinmux_lc_jtag_rsp
      }
      {
        package: jtag_pkg
        struct: jtag_req
        domain: Aon
        inter_pd: true
        signame: pinmux_rv_jtag_req_o
        signame_chip:
        {
          asic: pinmux_rv_jtag_req
          verilator: pinmux_rv_jtag_req
          cw340: pinmux_rv_jtag_req
        }
        width: 1
        type: req_rsp
        default: ""
        direction: out
        conn_type: false
        index: -1
        netname: pinmux_rv_jtag_req
      }
      {
        package: jtag_pkg
        struct: jtag_rsp
        domain: Aon
        inter_pd: true
        signame: pinmux_rv_jtag_rsp_i
        signame_chip:
        {
          asic: pinmux_rv_jtag_rsp
          verilator: pinmux_rv_jtag_rsp
          cw340: pinmux_rv_jtag_rsp
        }
        width: 1
        type: req_rsp
        default: ""
        direction: in
        conn_type: false
        index: -1
        netname: pinmux_rv_jtag_rsp
      }
      {
        package: jtag_pkg
        struct: jtag_req
        domain: Main
        inter_pd: true
        signame: pinmux_rv_jtag_req_i
        signame_chip:
        {
          asic: pinmux_rv_jtag_req
          verilator: pinmux_rv_jtag_req
          cw340: pinmux_rv_jtag_req
        }
        width: 1
        type: req_rsp
        default: ""
        direction: in
        conn_type: false
        index: -1
        netname: pinmux_rv_jtag_req
      }
      {
        package: jtag_pkg
        struct: jtag_rsp
        domain: Main
        inter_pd: true
        signame: pinmux_rv_jtag_rsp_o
        signame_chip:
        {
          asic: pinmux_rv_jtag_rsp
          verilator: pinmux_rv_jtag_rsp
          cw340: pinmux_rv_jtag_rsp
        }
        width: 1
        type: req_rsp
        default: ""
        direction: out
        conn_type: false
        index: -1
        netname: pinmux_rv_jtag_rsp
      }
      {
        package: jtag_pkg
        struct: jtag_req
        domain: Aon
        inter_pd: true
        signame: pinmux_rram_jtag_req_o
        signame_chip:
        {
          asic: pinmux_rram_jtag_req
          verilator: pinmux_rram_jtag_req
          cw340: pinmux_rram_jtag_req
        }
        width: 1
        type: req_rsp
        default: ""
        direction: out
        conn_type: false
        index: -1
        netname: pinmux_rram_jtag_req
      }
      {
        package: jtag_pkg
        struct: jtag_rsp
        domain: Aon
        inter_pd: true
        signame: pinmux_rram_jtag_rsp_i
        signame_chip:
        {
          asic: pinmux_rram_jtag_rsp
          verilator: pinmux_rram_jtag_rsp
          cw340: pinmux_rram_jtag_rsp
        }
        width: 1
        type: req_rsp
        default: ""
        direction: in
        conn_type: false
        index: -1
        netname: pinmux_rram_jtag_rsp
      }
      {
        package: jtag_pkg
        struct: jtag_req
        domain: Main
        inter_pd: true
        signame: pinmux_rram_jtag_req_i
        signame_chip:
        {
          asic: pinmux_rram_jtag_req
          verilator: pinmux_rram_jtag_req
          cw340: pinmux_rram_jtag_req
        }
        width: 1
        type: req_rsp
        default: ""
        direction: in
        conn_type: false
        index: -1
        netname: pinmux_rram_jtag_req
      }
      {
        package: jtag_pkg
        struct: jtag_rsp
        domain: Main
        inter_pd: true
        signame: pinmux_rram_jtag_rsp_o
        signame_chip:
        {
          asic: pinmux_rram_jtag_rsp
          verilator: pinmux_rram_jtag_rsp
          cw340: pinmux_rram_jtag_rsp
        }
        width: 1
        type: req_rsp
        default: ""
        direction: out
        conn_type: false
        index: -1
        netname: pinmux_rram_jtag_rsp
      }
      {
        package: lc_ctrl_pkg
        struct: lc_tx
        domain: Aon
        inter_pd: true
        signame: pinmux_pinmux_hw_debug_en_o
        signame_chip:
        {
          asic: pinmux_pinmux_hw_debug_en
          verilator: pinmux_pinmux_hw_debug_en
          cw340: pinmux_pinmux_hw_debug_en
        }
        width: 1
        type: uni
        default: lc_ctrl_pkg::Off
        direction: out
        conn_type: false
        index: -1
        netname: pinmux_pinmux_hw_debug_en
      }
      {
        package: lc_ctrl_pkg
        struct: lc_tx
        domain: Main
        inter_pd: true
        signame: pinmux_pinmux_hw_debug_en_i
        signame_chip:
        {
          asic: pinmux_pinmux_hw_debug_en
          verilator: pinmux_pinmux_hw_debug_en
          cw340: pinmux_pinmux_hw_debug_en
        }
        width: 1
        type: uni
        default: lc_ctrl_pkg::Off
        direction: in
        conn_type: false
        index: -1
        netname: pinmux_pinmux_hw_debug_en
      }
      {
        package: ""
        struct: logic
        domain: Main
        inter_pd: true
        signame: lc_ctrl_strap_en_override_o
        signame_chip:
        {
          asic: lc_ctrl_strap_en_override
          verilator: lc_ctrl_strap_en_override
          cw340: lc_ctrl_strap_en_override
        }
        width: 1
        type: uni
        default: 1'b0
        direction: out
        conn_type: false
        index: -1
        netname: lc_ctrl_strap_en_override
      }
      {
        package: ""
        struct: logic
        domain: Aon
        inter_pd: true
        signame: lc_ctrl_strap_en_override_i
        signame_chip:
        {
          asic: lc_ctrl_strap_en_override
          verilator: lc_ctrl_strap_en_override
          cw340: lc_ctrl_strap_en_override
        }
        width: 1
        type: uni
        default: 1'b0
        direction: in
        conn_type: false
        index: -1
        netname: lc_ctrl_strap_en_override
      }
      {
        package: lc_ctrl_pkg
        struct: lc_tx
        domain: Main
        inter_pd: true
        signame: lc_ctrl_lc_dft_en_o
        signame_chip:
        {
          asic: lc_ctrl_lc_dft_en
          verilator: lc_ctrl_lc_dft_en
          cw340: lc_ctrl_lc_dft_en
        }
        width: 1
        type: uni
        default: lc_ctrl_pkg::Off
        direction: out
        conn_type: true
        index: -1
        netname: lc_ctrl_lc_dft_en
      }
      {
        package: lc_ctrl_pkg
        struct: lc_tx
        domain: Aon
        inter_pd: true
        signame: lc_ctrl_lc_dft_en_i
        signame_chip:
        {
          asic: lc_ctrl_lc_dft_en
          verilator: lc_ctrl_lc_dft_en
          cw340: lc_ctrl_lc_dft_en
        }
        width: 1
        type: uni
        default: lc_ctrl_pkg::Off
        direction: in
        conn_type: false
        index: -1
        netname: lc_ctrl_lc_dft_en
      }
      {
        package: lc_ctrl_pkg
        struct: lc_tx
        domain: Main
        inter_pd: true
        signame: lc_ctrl_lc_nvm_debug_en_o
        signame_chip:
        {
          asic: lc_ctrl_lc_nvm_debug_en
          verilator: lc_ctrl_lc_nvm_debug_en
          cw340: lc_ctrl_lc_nvm_debug_en
        }
        width: 1
        type: uni
        default: lc_ctrl_pkg::Off
        direction: out
        conn_type: true
        index: -1
        netname: lc_ctrl_lc_nvm_debug_en
      }
      {
        package: lc_ctrl_pkg
        struct: lc_tx
        domain: Aon
        inter_pd: true
        signame: lc_ctrl_lc_nvm_debug_en_i
        signame_chip:
        {
          asic: lc_ctrl_lc_nvm_debug_en
          verilator: lc_ctrl_lc_nvm_debug_en
          cw340: lc_ctrl_lc_nvm_debug_en
        }
        width: 1
        type: uni
        default: lc_ctrl_pkg::Off
        direction: in
        conn_type: false
        index: -1
        netname: lc_ctrl_lc_nvm_debug_en
      }
      {
        package: lc_ctrl_pkg
        struct: lc_tx
        domain: Main
        inter_pd: true
        signame: lc_ctrl_lc_hw_debug_clr_o
        signame_chip:
        {
          asic: lc_ctrl_lc_hw_debug_clr
          verilator: lc_ctrl_lc_hw_debug_clr
          cw340: lc_ctrl_lc_hw_debug_clr
        }
        width: 1
        type: uni
        default: lc_ctrl_pkg::Off
        direction: out
        conn_type: true
        index: -1
        netname: lc_ctrl_lc_hw_debug_clr
      }
      {
        package: lc_ctrl_pkg
        struct: lc_tx
        domain: Aon
        inter_pd: true
        signame: lc_ctrl_lc_hw_debug_clr_i
        signame_chip:
        {
          asic: lc_ctrl_lc_hw_debug_clr
          verilator: lc_ctrl_lc_hw_debug_clr
          cw340: lc_ctrl_lc_hw_debug_clr
        }
        width: 1
        type: uni
        default: lc_ctrl_pkg::Off
        direction: in
        conn_type: false
        index: -1
        netname: lc_ctrl_lc_hw_debug_clr
      }
      {
        package: lc_ctrl_pkg
        struct: lc_tx
        domain: Main
        inter_pd: true
        signame: lc_ctrl_lc_hw_debug_en_o
        signame_chip:
        {
          asic: lc_ctrl_lc_hw_debug_en
          verilator: lc_ctrl_lc_hw_debug_en
          cw340: lc_ctrl_lc_hw_debug_en
        }
        width: 1
        type: uni
        default: lc_ctrl_pkg::Off
        direction: out
        conn_type: true
        index: -1
        netname: lc_ctrl_lc_hw_debug_en
      }
      {
        package: lc_ctrl_pkg
        struct: lc_tx
        domain: Aon
        inter_pd: true
        signame: lc_ctrl_lc_hw_debug_en_i
        signame_chip:
        {
          asic: lc_ctrl_lc_hw_debug_en
          verilator: lc_ctrl_lc_hw_debug_en
          cw340: lc_ctrl_lc_hw_debug_en
        }
        width: 1
        type: uni
        default: lc_ctrl_pkg::Off
        direction: in
        conn_type: false
        index: -1
        netname: lc_ctrl_lc_hw_debug_en
      }
      {
        package: lc_ctrl_pkg
        struct: lc_tx
        domain: Main
        inter_pd: true
        signame: lc_ctrl_lc_escalate_en_o
        signame_chip:
        {
          asic: lc_ctrl_lc_escalate_en
          verilator: lc_ctrl_lc_escalate_en
          cw340: lc_ctrl_lc_escalate_en
        }
        width: 1
        type: uni
        default: lc_ctrl_pkg::Off
        direction: out
        conn_type: true
        index: -1
        netname: lc_ctrl_lc_escalate_en
      }
      {
        package: lc_ctrl_pkg
        struct: lc_tx
        domain: Aon
        inter_pd: true
        signame: lc_ctrl_lc_escalate_en_i
        signame_chip:
        {
          asic: lc_ctrl_lc_escalate_en
          verilator: lc_ctrl_lc_escalate_en
          cw340: lc_ctrl_lc_escalate_en
        }
        width: 1
        type: uni
        default: lc_ctrl_pkg::Off
        direction: in
        conn_type: false
        index: -1
        netname: lc_ctrl_lc_escalate_en
      }
      {
        package: lc_ctrl_pkg
        struct: lc_tx
        domain: Main
        inter_pd: true
        signame: lc_ctrl_lc_check_byp_en_o
        signame_chip:
        {
          asic: lc_ctrl_lc_check_byp_en
          verilator: lc_ctrl_lc_check_byp_en
          cw340: lc_ctrl_lc_check_byp_en
        }
        width: 1
        type: uni
        default: lc_ctrl_pkg::Off
        direction: out
        conn_type: true
        index: -1
        netname: lc_ctrl_lc_check_byp_en
      }
      {
        package: lc_ctrl_pkg
        struct: lc_tx
        domain: Aon
        inter_pd: true
        signame: lc_ctrl_lc_check_byp_en_i
        signame_chip:
        {
          asic: lc_ctrl_lc_check_byp_en
          verilator: lc_ctrl_lc_check_byp_en
          cw340: lc_ctrl_lc_check_byp_en
        }
        width: 1
        type: uni
        default: lc_ctrl_pkg::Off
        direction: in
        conn_type: false
        index: -1
        netname: lc_ctrl_lc_check_byp_en
      }
      {
        package: lc_ctrl_pkg
        struct: lc_tx
        domain: Main
        inter_pd: true
        signame: lc_ctrl_lc_clk_byp_req_o
        signame_chip:
        {
          asic: lc_ctrl_lc_clk_byp_req
          verilator: lc_ctrl_lc_clk_byp_req
          cw340: lc_ctrl_lc_clk_byp_req
        }
        width: 1
        type: uni
        default: lc_ctrl_pkg::Off
        direction: out
        conn_type: false
        index: -1
        netname: lc_ctrl_lc_clk_byp_req
      }
      {
        package: lc_ctrl_pkg
        struct: lc_tx
        domain: Aon
        inter_pd: true
        signame: lc_ctrl_lc_clk_byp_req_i
        signame_chip:
        {
          asic: lc_ctrl_lc_clk_byp_req
          verilator: lc_ctrl_lc_clk_byp_req
          cw340: lc_ctrl_lc_clk_byp_req
        }
        width: 1
        type: uni
        default: lc_ctrl_pkg::Off
        direction: in
        conn_type: false
        index: -1
        netname: lc_ctrl_lc_clk_byp_req
      }
      {
        package: lc_ctrl_pkg
        struct: lc_tx
        domain: Main
        inter_pd: true
        signame: lc_ctrl_lc_clk_byp_ack_i
        signame_chip:
        {
          asic: lc_ctrl_lc_clk_byp_ack
          verilator: lc_ctrl_lc_clk_byp_ack
          cw340: lc_ctrl_lc_clk_byp_ack
        }
        width: 1
        type: uni
        default: lc_ctrl_pkg::Off
        direction: in
        conn_type: false
        index: -1
        netname: lc_ctrl_lc_clk_byp_ack
      }
      {
        package: lc_ctrl_pkg
        struct: lc_tx
        domain: Aon
        inter_pd: true
        signame: lc_ctrl_lc_clk_byp_ack_o
        signame_chip:
        {
          asic: lc_ctrl_lc_clk_byp_ack
          verilator: lc_ctrl_lc_clk_byp_ack
          cw340: lc_ctrl_lc_clk_byp_ack
        }
        width: 1
        type: uni
        default: lc_ctrl_pkg::Off
        direction: out
        conn_type: false
        index: -1
        netname: lc_ctrl_lc_clk_byp_ack
      }
      {
        package: rv_core_ibex_pkg
        struct: cpu_crash_dump
        domain: Main
        inter_pd: true
        signame: rv_core_ibex_crash_dump_o
        signame_chip:
        {
          asic: rv_core_ibex_crash_dump
          verilator: rv_core_ibex_crash_dump
          cw340: rv_core_ibex_crash_dump
        }
        width: 1
        type: uni
        default: ""
        direction: out
        conn_type: false
        index: -1
        netname: rv_core_ibex_crash_dump
      }
      {
        package: rv_core_ibex_pkg
        struct: cpu_crash_dump
        domain: Aon
        inter_pd: true
        signame: rv_core_ibex_crash_dump_i
        signame_chip:
        {
          asic: rv_core_ibex_crash_dump
          verilator: rv_core_ibex_crash_dump
          cw340: rv_core_ibex_crash_dump
        }
        width: 1
        type: uni
        default: ""
        direction: in
        conn_type: false
        index: -1
        netname: rv_core_ibex_crash_dump
      }
      {
        package: rv_core_ibex_pkg
        struct: cpu_pwrmgr
        domain: Main
        inter_pd: true
        signame: rv_core_ibex_pwrmgr_o
        signame_chip:
        {
          asic: rv_core_ibex_pwrmgr
          verilator: rv_core_ibex_pwrmgr
          cw340: rv_core_ibex_pwrmgr
        }
        width: 1
        type: uni
        default: ""
        direction: out
        conn_type: false
        index: -1
        netname: rv_core_ibex_pwrmgr
      }
      {
        package: rv_core_ibex_pkg
        struct: cpu_pwrmgr
        domain: Aon
        inter_pd: true
        signame: rv_core_ibex_pwrmgr_i
        signame_chip:
        {
          asic: rv_core_ibex_pwrmgr
          verilator: rv_core_ibex_pwrmgr
          cw340: rv_core_ibex_pwrmgr
        }
        width: 1
        type: uni
        default: ""
        direction: in
        conn_type: false
        index: -1
        netname: rv_core_ibex_pwrmgr
      }
      {
        package: ""
        struct: logic
        domain: Main
        inter_pd: true
        signame: rv_dm_ndmreset_req_o
        signame_chip:
        {
          asic: rv_dm_ndmreset_req
          verilator: rv_dm_ndmreset_req
          cw340: rv_dm_ndmreset_req
        }
        width: 1
        type: uni
        default: ""
        direction: out
        conn_type: false
        index: -1
        netname: rv_dm_ndmreset_req
      }
      {
        package: ""
        struct: logic
        domain: Aon
        inter_pd: true
        signame: rv_dm_ndmreset_req_i
        signame_chip:
        {
          asic: rv_dm_ndmreset_req
          verilator: rv_dm_ndmreset_req
          cw340: rv_dm_ndmreset_req
        }
        width: 1
        type: uni
        default: ""
        direction: in
        conn_type: false
        index: -1
        netname: rv_dm_ndmreset_req
      }
      {
        package: ""
        struct: logic
        domain: Aon
        inter_pd: true
        signame: pwrmgr_wakeups_i
        signame_chip:
        {
          asic: pwrmgr_wakeups
          verilator: pwrmgr_wakeups
          cw340: pwrmgr_wakeups
        }
        width: 1
        type: uni
        default: ""
        direction: in
        conn_type: true
        index: 1
        netname: pwrmgr_wakeups
      }
      {
        package: ""
        struct: logic
        domain: Main
        inter_pd: true
        signame: pwrmgr_wakeups_o
        signame_chip:
        {
          asic: pwrmgr_wakeups
          verilator: pwrmgr_wakeups
          cw340: pwrmgr_wakeups
        }
        width: 1
        type: uni
        default: ""
        direction: out
        conn_type: false
        index: 1
        netname: pwrmgr_wakeups
      }
      {
        package: ""
        struct: logic
        domain: Main
        inter_pd: true
        signame: i3c0_rstdet_enable_o
        signame_chip:
        {
          asic: i3c0_rstdet_enable
          verilator: i3c0_rstdet_enable
          cw340: i3c0_rstdet_enable
        }
        width: 1
        type: uni
        default: ""
        direction: out
        conn_type: false
        index: -1
        netname: i3c0_rstdet_enable
      }
      {
        package: ""
        struct: logic
        domain: Aon
        inter_pd: true
        signame: i3c0_rstdet_enable_i
        signame_chip:
        {
          asic: i3c0_rstdet_enable
          verilator: i3c0_rstdet_enable
          cw340: i3c0_rstdet_enable
        }
        width: 1
        type: uni
        default: ""
        direction: in
        conn_type: false
        index: -1
        netname: i3c0_rstdet_enable
      }
      {
        package: i3c_pkg
        struct: i3c_rstdet_req
        domain: Main
        inter_pd: true
        signame: i3c0_rstdet_req_o
        signame_chip:
        {
          asic: i3c0_rstdet_req
          verilator: i3c0_rstdet_req
          cw340: i3c0_rstdet_req
        }
        width: 1
        type: req_rsp
        default: ""
        direction: out
        conn_type: false
        index: -1
        netname: i3c0_rstdet_req
      }
      {
        package: i3c_pkg
        struct: i3c_rstdet_rsp
        domain: Main
        inter_pd: true
        signame: i3c0_rstdet_rsp_i
        signame_chip:
        {
          asic: i3c0_rstdet_rsp
          verilator: i3c0_rstdet_rsp
          cw340: i3c0_rstdet_rsp
        }
        width: 1
        type: req_rsp
        default: ""
        direction: in
        conn_type: false
        index: -1
        netname: i3c0_rstdet_rsp
      }
      {
        package: i3c_pkg
        struct: i3c_rstdet_req
        domain: Aon
        inter_pd: true
        signame: i3c0_rstdet_req_i
        signame_chip:
        {
          asic: i3c0_rstdet_req
          verilator: i3c0_rstdet_req
          cw340: i3c0_rstdet_req
        }
        width: 1
        type: req_rsp
        default: ""
        direction: in
        conn_type: false
        index: -1
        netname: i3c0_rstdet_req
      }
      {
        package: i3c_pkg
        struct: i3c_rstdet_rsp
        domain: Aon
        inter_pd: true
        signame: i3c0_rstdet_rsp_o
        signame_chip:
        {
          asic: i3c0_rstdet_rsp
          verilator: i3c0_rstdet_rsp
          cw340: i3c0_rstdet_rsp
        }
        width: 1
        type: req_rsp
        default: ""
        direction: out
        conn_type: false
        index: -1
        netname: i3c0_rstdet_rsp
      }
      {
        package: ast_intraip_pkg
        struct: s2p
        domain: Aon
        inter_pd: true
        signame: ast_intraip_s2p_o
        signame_chip:
        {
          asic: ast_intraip_s2p
          verilator: ast_intraip_s2p
          cw340: ast_intraip_s2p
        }
        width: 1
        type: uni
        default: ""
        direction: out
        conn_type: false
        index: -1
        netname: ast_intraip_s2p
      }
      {
        package: ast_intraip_pkg
        struct: s2p
        domain: Main
        inter_pd: true
        signame: ast_intraip_s2p_i
        signame_chip:
        {
          asic: ast_intraip_s2p
          verilator: ast_intraip_s2p
          cw340: ast_intraip_s2p
        }
        width: 1
        type: uni
        default: ""
        direction: in
        conn_type: false
        index: -1
        netname: ast_intraip_s2p
      }
      {
        package: ast_intraip_pkg
        struct: p2s
        domain: Main
        inter_pd: true
        signame: ast_intraip_p2s_o
        signame_chip:
        {
          asic: ast_intraip_p2s
          verilator: ast_intraip_p2s
          cw340: ast_intraip_p2s
        }
        width: 1
        type: uni
        default: ""
        direction: out
        conn_type: false
        index: -1
        netname: ast_intraip_p2s
      }
      {
        package: ast_intraip_pkg
        struct: p2s
        domain: Aon
        inter_pd: true
        signame: ast_intraip_p2s_i
        signame_chip:
        {
          asic: ast_intraip_p2s
          verilator: ast_intraip_p2s
          cw340: ast_intraip_p2s
        }
        width: 1
        type: uni
        default: ""
        direction: in
        conn_type: false
        index: -1
        netname: ast_intraip_p2s
      }
      {
        package: tlul_pkg
        struct: tl_h2d
        domain: Aon
        inter_pd: true
        signame: pwrmgr_tl_req_i
        signame_chip:
        {
          asic: pwrmgr_tl_req
          verilator: pwrmgr_tl_req
          cw340: pwrmgr_tl_req
        }
        width: 1
        type: req_rsp
        default: ""
        direction: in
        conn_type: false
        index: -1
        netname: pwrmgr_tl_h2d
      }
      {
        package: tlul_pkg
        struct: tl_d2h
        domain: Aon
        inter_pd: true
        signame: pwrmgr_tl_rsp_o
        signame_chip:
        {
          asic: pwrmgr_tl_rsp
          verilator: pwrmgr_tl_rsp
          cw340: pwrmgr_tl_rsp
        }
        width: 1
        type: req_rsp
        default: ""
        direction: out
        conn_type: false
        index: -1
        netname: pwrmgr_tl_d2h
      }
      {
        package: tlul_pkg
        struct: tl_h2d
        domain: Main
        inter_pd: true
        signame: pwrmgr_tl_req_o
        signame_chip:
        {
          asic: pwrmgr_tl_req
          verilator: pwrmgr_tl_req
          cw340: pwrmgr_tl_req
        }
        width: 1
        type: req_rsp
        default: ""
        direction: out
        conn_type: false
        index: -1
        netname: pwrmgr_tl_h2d
      }
      {
        package: tlul_pkg
        struct: tl_d2h
        domain: Main
        inter_pd: true
        signame: pwrmgr_tl_rsp_i
        signame_chip:
        {
          asic: pwrmgr_tl_rsp
          verilator: pwrmgr_tl_rsp
          cw340: pwrmgr_tl_rsp
        }
        width: 1
        type: req_rsp
        default: ""
        direction: in
        conn_type: false
        index: -1
        netname: pwrmgr_tl_d2h
      }
      {
        package: tlul_pkg
        struct: tl_h2d
        domain: Aon
        inter_pd: true
        signame: rstmgr_tl_req_i
        signame_chip:
        {
          asic: rstmgr_tl_req
          verilator: rstmgr_tl_req
          cw340: rstmgr_tl_req
        }
        width: 1
        type: req_rsp
        default: ""
        direction: in
        conn_type: false
        index: -1
        netname: rstmgr_tl_h2d
      }
      {
        package: tlul_pkg
        struct: tl_d2h
        domain: Aon
        inter_pd: true
        signame: rstmgr_tl_rsp_o
        signame_chip:
        {
          asic: rstmgr_tl_rsp
          verilator: rstmgr_tl_rsp
          cw340: rstmgr_tl_rsp
        }
        width: 1
        type: req_rsp
        default: ""
        direction: out
        conn_type: false
        index: -1
        netname: rstmgr_tl_d2h
      }
      {
        package: tlul_pkg
        struct: tl_h2d
        domain: Main
        inter_pd: true
        signame: rstmgr_tl_req_o
        signame_chip:
        {
          asic: rstmgr_tl_req
          verilator: rstmgr_tl_req
          cw340: rstmgr_tl_req
        }
        width: 1
        type: req_rsp
        default: ""
        direction: out
        conn_type: false
        index: -1
        netname: rstmgr_tl_h2d
      }
      {
        package: tlul_pkg
        struct: tl_d2h
        domain: Main
        inter_pd: true
        signame: rstmgr_tl_rsp_i
        signame_chip:
        {
          asic: rstmgr_tl_rsp
          verilator: rstmgr_tl_rsp
          cw340: rstmgr_tl_rsp
        }
        width: 1
        type: req_rsp
        default: ""
        direction: in
        conn_type: false
        index: -1
        netname: rstmgr_tl_d2h
      }
      {
        package: tlul_pkg
        struct: tl_h2d
        domain: Aon
        inter_pd: true
        signame: clkmgr_tl_req_i
        signame_chip:
        {
          asic: clkmgr_tl_req
          verilator: clkmgr_tl_req
          cw340: clkmgr_tl_req
        }
        width: 1
        type: req_rsp
        default: ""
        direction: in
        conn_type: false
        index: -1
        netname: clkmgr_tl_h2d
      }
      {
        package: tlul_pkg
        struct: tl_d2h
        domain: Aon
        inter_pd: true
        signame: clkmgr_tl_rsp_o
        signame_chip:
        {
          asic: clkmgr_tl_rsp
          verilator: clkmgr_tl_rsp
          cw340: clkmgr_tl_rsp
        }
        width: 1
        type: req_rsp
        default: ""
        direction: out
        conn_type: false
        index: -1
        netname: clkmgr_tl_d2h
      }
      {
        package: tlul_pkg
        struct: tl_h2d
        domain: Main
        inter_pd: true
        signame: clkmgr_tl_req_o
        signame_chip:
        {
          asic: clkmgr_tl_req
          verilator: clkmgr_tl_req
          cw340: clkmgr_tl_req
        }
        width: 1
        type: req_rsp
        default: ""
        direction: out
        conn_type: false
        index: -1
        netname: clkmgr_tl_h2d
      }
      {
        package: tlul_pkg
        struct: tl_d2h
        domain: Main
        inter_pd: true
        signame: clkmgr_tl_rsp_i
        signame_chip:
        {
          asic: clkmgr_tl_rsp
          verilator: clkmgr_tl_rsp
          cw340: clkmgr_tl_rsp
        }
        width: 1
        type: req_rsp
        default: ""
        direction: in
        conn_type: false
        index: -1
        netname: clkmgr_tl_d2h
      }
      {
        package: tlul_pkg
        struct: tl_h2d
        domain: Aon
        inter_pd: true
        signame: pinmux_tl_req_i
        signame_chip:
        {
          asic: pinmux_tl_req
          verilator: pinmux_tl_req
          cw340: pinmux_tl_req
        }
        width: 1
        type: req_rsp
        default: ""
        direction: in
        conn_type: false
        index: -1
        netname: pinmux_tl_h2d
      }
      {
        package: tlul_pkg
        struct: tl_d2h
        domain: Aon
        inter_pd: true
        signame: pinmux_tl_rsp_o
        signame_chip:
        {
          asic: pinmux_tl_rsp
          verilator: pinmux_tl_rsp
          cw340: pinmux_tl_rsp
        }
        width: 1
        type: req_rsp
        default: ""
        direction: out
        conn_type: false
        index: -1
        netname: pinmux_tl_d2h
      }
      {
        package: tlul_pkg
        struct: tl_h2d
        domain: Main
        inter_pd: true
        signame: pinmux_tl_req_o
        signame_chip:
        {
          asic: pinmux_tl_req
          verilator: pinmux_tl_req
          cw340: pinmux_tl_req
        }
        width: 1
        type: req_rsp
        default: ""
        direction: out
        conn_type: false
        index: -1
        netname: pinmux_tl_h2d
      }
      {
        package: tlul_pkg
        struct: tl_d2h
        domain: Main
        inter_pd: true
        signame: pinmux_tl_rsp_i
        signame_chip:
        {
          asic: pinmux_tl_rsp
          verilator: pinmux_tl_rsp
          cw340: pinmux_tl_rsp
        }
        width: 1
        type: req_rsp
        default: ""
        direction: in
        conn_type: false
        index: -1
        netname: pinmux_tl_d2h
      }
      {
        package: tlul_pkg
        struct: tl_h2d
        domain: Aon
        inter_pd: true
        signame: sensor_ctrl_tl_req_i
        signame_chip:
        {
          asic: sensor_ctrl_tl_req
          verilator: sensor_ctrl_tl_req
          cw340: sensor_ctrl_tl_req
        }
        width: 1
        type: req_rsp
        default: ""
        direction: in
        conn_type: false
        index: -1
        netname: sensor_ctrl_tl_h2d
      }
      {
        package: tlul_pkg
        struct: tl_d2h
        domain: Aon
        inter_pd: true
        signame: sensor_ctrl_tl_rsp_o
        signame_chip:
        {
          asic: sensor_ctrl_tl_rsp
          verilator: sensor_ctrl_tl_rsp
          cw340: sensor_ctrl_tl_rsp
        }
        width: 1
        type: req_rsp
        default: ""
        direction: out
        conn_type: false
        index: -1
        netname: sensor_ctrl_tl_d2h
      }
      {
        package: tlul_pkg
        struct: tl_h2d
        domain: Main
        inter_pd: true
        signame: sensor_ctrl_tl_req_o
        signame_chip:
        {
          asic: sensor_ctrl_tl_req
          verilator: sensor_ctrl_tl_req
          cw340: sensor_ctrl_tl_req
        }
        width: 1
        type: req_rsp
        default: ""
        direction: out
        conn_type: false
        index: -1
        netname: sensor_ctrl_tl_h2d
      }
      {
        package: tlul_pkg
        struct: tl_d2h
        domain: Main
        inter_pd: true
        signame: sensor_ctrl_tl_rsp_i
        signame_chip:
        {
          asic: sensor_ctrl_tl_rsp
          verilator: sensor_ctrl_tl_rsp
          cw340: sensor_ctrl_tl_rsp
        }
        width: 1
        type: req_rsp
        default: ""
        direction: in
        conn_type: false
        index: -1
        netname: sensor_ctrl_tl_d2h
      }
      {
        package: tlul_pkg
        struct: tl_h2d
        domain: Aon
        inter_pd: true
        signame: sram_ctrl_ret_regs_tl_req_i
        signame_chip:
        {
          asic: sram_ctrl_ret_regs_tl_req
          verilator: sram_ctrl_ret_regs_tl_req
          cw340: sram_ctrl_ret_regs_tl_req
        }
        width: 1
        type: req_rsp
        default: ""
        direction: in
        conn_type: false
        index: -1
        netname: sram_ctrl_ret_regs_tl_h2d
      }
      {
        package: tlul_pkg
        struct: tl_d2h
        domain: Aon
        inter_pd: true
        signame: sram_ctrl_ret_regs_tl_rsp_o
        signame_chip:
        {
          asic: sram_ctrl_ret_regs_tl_rsp
          verilator: sram_ctrl_ret_regs_tl_rsp
          cw340: sram_ctrl_ret_regs_tl_rsp
        }
        width: 1
        type: req_rsp
        default: ""
        direction: out
        conn_type: false
        index: -1
        netname: sram_ctrl_ret_regs_tl_d2h
      }
      {
        package: tlul_pkg
        struct: tl_h2d
        domain: Main
        inter_pd: true
        signame: sram_ctrl_ret_regs_tl_req_o
        signame_chip:
        {
          asic: sram_ctrl_ret_regs_tl_req
          verilator: sram_ctrl_ret_regs_tl_req
          cw340: sram_ctrl_ret_regs_tl_req
        }
        width: 1
        type: req_rsp
        default: ""
        direction: out
        conn_type: false
        index: -1
        netname: sram_ctrl_ret_regs_tl_h2d
      }
      {
        package: tlul_pkg
        struct: tl_d2h
        domain: Main
        inter_pd: true
        signame: sram_ctrl_ret_regs_tl_rsp_i
        signame_chip:
        {
          asic: sram_ctrl_ret_regs_tl_rsp
          verilator: sram_ctrl_ret_regs_tl_rsp
          cw340: sram_ctrl_ret_regs_tl_rsp
        }
        width: 1
        type: req_rsp
        default: ""
        direction: in
        conn_type: false
        index: -1
        netname: sram_ctrl_ret_regs_tl_d2h
      }
      {
        package: tlul_pkg
        struct: tl_h2d
        domain: Aon
        inter_pd: true
        signame: sram_ctrl_ret_ram_tl_req_i
        signame_chip:
        {
          asic: sram_ctrl_ret_ram_tl_req
          verilator: sram_ctrl_ret_ram_tl_req
          cw340: sram_ctrl_ret_ram_tl_req
        }
        width: 1
        type: req_rsp
        default: ""
        direction: in
        conn_type: false
        index: -1
        netname: sram_ctrl_ret_ram_tl_h2d
      }
      {
        package: tlul_pkg
        struct: tl_d2h
        domain: Aon
        inter_pd: true
        signame: sram_ctrl_ret_ram_tl_rsp_o
        signame_chip:
        {
          asic: sram_ctrl_ret_ram_tl_rsp
          verilator: sram_ctrl_ret_ram_tl_rsp
          cw340: sram_ctrl_ret_ram_tl_rsp
        }
        width: 1
        type: req_rsp
        default: ""
        direction: out
        conn_type: false
        index: -1
        netname: sram_ctrl_ret_ram_tl_d2h
      }
      {
        package: tlul_pkg
        struct: tl_h2d
        domain: Main
        inter_pd: true
        signame: sram_ctrl_ret_ram_tl_req_o
        signame_chip:
        {
          asic: sram_ctrl_ret_ram_tl_req
          verilator: sram_ctrl_ret_ram_tl_req
          cw340: sram_ctrl_ret_ram_tl_req
        }
        width: 1
        type: req_rsp
        default: ""
        direction: out
        conn_type: false
        index: -1
        netname: sram_ctrl_ret_ram_tl_h2d
      }
      {
        package: tlul_pkg
        struct: tl_d2h
        domain: Main
        inter_pd: true
        signame: sram_ctrl_ret_ram_tl_rsp_i
        signame_chip:
        {
          asic: sram_ctrl_ret_ram_tl_rsp
          verilator: sram_ctrl_ret_ram_tl_rsp
          cw340: sram_ctrl_ret_ram_tl_rsp
        }
        width: 1
        type: req_rsp
        default: ""
        direction: in
        conn_type: false
        index: -1
        netname: sram_ctrl_ret_ram_tl_d2h
      }
      {
        package: tlul_pkg
        struct: tl_h2d
        domain: Aon
        inter_pd: true
        signame: aon_timer_tl_req_i
        signame_chip:
        {
          asic: aon_timer_tl_req
          verilator: aon_timer_tl_req
          cw340: aon_timer_tl_req
        }
        width: 1
        type: req_rsp
        default: ""
        direction: in
        conn_type: false
        index: -1
        netname: aon_timer_tl_h2d
      }
      {
        package: tlul_pkg
        struct: tl_d2h
        domain: Aon
        inter_pd: true
        signame: aon_timer_tl_rsp_o
        signame_chip:
        {
          asic: aon_timer_tl_rsp
          verilator: aon_timer_tl_rsp
          cw340: aon_timer_tl_rsp
        }
        width: 1
        type: req_rsp
        default: ""
        direction: out
        conn_type: false
        index: -1
        netname: aon_timer_tl_d2h
      }
      {
        package: tlul_pkg
        struct: tl_h2d
        domain: Main
        inter_pd: true
        signame: aon_timer_tl_req_o
        signame_chip:
        {
          asic: aon_timer_tl_req
          verilator: aon_timer_tl_req
          cw340: aon_timer_tl_req
        }
        width: 1
        type: req_rsp
        default: ""
        direction: out
        conn_type: false
        index: -1
        netname: aon_timer_tl_h2d
      }
      {
        package: tlul_pkg
        struct: tl_d2h
        domain: Main
        inter_pd: true
        signame: aon_timer_tl_rsp_i
        signame_chip:
        {
          asic: aon_timer_tl_rsp
          verilator: aon_timer_tl_rsp
          cw340: aon_timer_tl_rsp
        }
        width: 1
        type: req_rsp
        default: ""
        direction: in
        conn_type: false
        index: -1
        netname: aon_timer_tl_d2h
      }
      {
        package: tlul_pkg
        struct: tl_h2d
        domain: Aon
        inter_pd: true
        signame: sysrst_ctrl_tl_req_i
        signame_chip:
        {
          asic: sysrst_ctrl_tl_req
          verilator: sysrst_ctrl_tl_req
          cw340: sysrst_ctrl_tl_req
        }
        width: 1
        type: req_rsp
        default: ""
        direction: in
        conn_type: false
        index: -1
        netname: sysrst_ctrl_tl_h2d
      }
      {
        package: tlul_pkg
        struct: tl_d2h
        domain: Aon
        inter_pd: true
        signame: sysrst_ctrl_tl_rsp_o
        signame_chip:
        {
          asic: sysrst_ctrl_tl_rsp
          verilator: sysrst_ctrl_tl_rsp
          cw340: sysrst_ctrl_tl_rsp
        }
        width: 1
        type: req_rsp
        default: ""
        direction: out
        conn_type: false
        index: -1
        netname: sysrst_ctrl_tl_d2h
      }
      {
        package: tlul_pkg
        struct: tl_h2d
        domain: Main
        inter_pd: true
        signame: sysrst_ctrl_tl_req_o
        signame_chip:
        {
          asic: sysrst_ctrl_tl_req
          verilator: sysrst_ctrl_tl_req
          cw340: sysrst_ctrl_tl_req
        }
        width: 1
        type: req_rsp
        default: ""
        direction: out
        conn_type: false
        index: -1
        netname: sysrst_ctrl_tl_h2d
      }
      {
        package: tlul_pkg
        struct: tl_d2h
        domain: Main
        inter_pd: true
        signame: sysrst_ctrl_tl_rsp_i
        signame_chip:
        {
          asic: sysrst_ctrl_tl_rsp
          verilator: sysrst_ctrl_tl_rsp
          cw340: sysrst_ctrl_tl_rsp
        }
        width: 1
        type: req_rsp
        default: ""
        direction: in
        conn_type: false
        index: -1
        netname: sysrst_ctrl_tl_d2h
      }
      {
        package: tlul_pkg
        struct: tl_h2d
        domain: Aon
        inter_pd: true
        signame: adc_ctrl_tl_req_i
        signame_chip:
        {
          asic: adc_ctrl_tl_req
          verilator: adc_ctrl_tl_req
          cw340: adc_ctrl_tl_req
        }
        width: 1
        type: req_rsp
        default: ""
        direction: in
        conn_type: false
        index: -1
        netname: adc_ctrl_tl_h2d
      }
      {
        package: tlul_pkg
        struct: tl_d2h
        domain: Aon
        inter_pd: true
        signame: adc_ctrl_tl_rsp_o
        signame_chip:
        {
          asic: adc_ctrl_tl_rsp
          verilator: adc_ctrl_tl_rsp
          cw340: adc_ctrl_tl_rsp
        }
        width: 1
        type: req_rsp
        default: ""
        direction: out
        conn_type: false
        index: -1
        netname: adc_ctrl_tl_d2h
      }
      {
        package: tlul_pkg
        struct: tl_h2d
        domain: Main
        inter_pd: true
        signame: adc_ctrl_tl_req_o
        signame_chip:
        {
          asic: adc_ctrl_tl_req
          verilator: adc_ctrl_tl_req
          cw340: adc_ctrl_tl_req
        }
        width: 1
        type: req_rsp
        default: ""
        direction: out
        conn_type: false
        index: -1
        netname: adc_ctrl_tl_h2d
      }
      {
        package: tlul_pkg
        struct: tl_d2h
        domain: Main
        inter_pd: true
        signame: adc_ctrl_tl_rsp_i
        signame_chip:
        {
          asic: adc_ctrl_tl_rsp
          verilator: adc_ctrl_tl_rsp
          cw340: adc_ctrl_tl_rsp
        }
        width: 1
        type: req_rsp
        default: ""
        direction: in
        conn_type: false
        index: -1
        netname: adc_ctrl_tl_d2h
      }
      {
        package: ""
        struct: logic
        domain: Aon
        inter_pd: false
        signame: manual_in_por_n_i
        signame_chip:
        {
          asic: manual_in_por_n
          verilator: rst_n
          cw340: rst_n
        }
        width: 1
        type: uni
        default: ""
        direction: in
        conn_type: false
        index: -1
        netname: manual_in_por_n
      }
      {
        package: ""
        struct: logic
        domain: Aon
        inter_pd: false
        signame: manual_in_pora_n_i
        signame_chip:
        {
          asic: manual_in_pora_n
          verilator: rst_n
          cw340: rst_n
        }
        width: 1
        type: uni
        default: ""
        direction: in
        conn_type: false
        index: -1
        netname: manual_in_pora_n
      }
      {
        package: prim_mubi_pkg
        struct: mubi4
        domain: Aon
        inter_pd: false
        signame: scanmode_o
        signame_chip:
        {
          asic: scanmode
          verilator: scanmode
          cw340: scanmode
        }
        width: 1
        type: uni
        default: ""
        direction: out
        conn_type: false
        index: -1
        netname: scanmode
      }
      {
        package: ""
        struct: logic
        domain: Aon
        inter_pd: false
        signame: scan_en_o
        signame_chip:
        {
          asic: ""
          verilator: ""
          cw340: ""
        }
        width: 1
        type: uni
        default: ""
        direction: out
        conn_type: false
        index: -1
        netname: scan_en
      }
      {
        package: ""
        struct: logic
        domain: Aon
        inter_pd: false
        signame: scan_rst_n_o
        signame_chip:
        {
          asic: ""
          verilator: ""
          cw340: ""
        }
        width: 1
        type: uni
        default: ""
        direction: out
        conn_type: false
        index: -1
        netname: scan_rst_n
      }
      {
        package: ""
        struct: logic
        domain: Aon
        inter_pd: false
        signame: usb_io_pu_cal_o
        signame_chip:
        {
          asic: usb_io_pu_cal
          verilator: ""
          cw340: ""
        }
        width:
        {
          name: UsbCalibWidth
          desc: Width of the USB IO pull-up calibration setting
          param_type: int unsigned
          unpacked_dimensions: null
          partition: secondary
          default: 20
          local: false
          expose: true
          name_top: AstUsbCalibWidth
        }
        type: uni
        default: ""
        direction: out
        conn_type: false
        index: -1
        netname: usb_io_pu_cal
      }
      {
        package: ""
        struct: logic
        domain: Aon
        inter_pd: false
        signame: padmux2ast_i
        signame_chip:
        {
          asic: padmux2ast
          verilator: padmux2ast
          cw340: padmux2ast
        }
        width:
        {
          name: Pad2AstInWidth
          desc: Width of the DFT pad-to-AST input signal bus
          param_type: int unsigned
          unpacked_dimensions: null
          partition: secondary
          default: 8
          local: false
          expose: true
          name_top: AstPad2AstInWidth
        }
        type: uni
        default: ""
        direction: in
        conn_type: false
        index: -1
        netname: padmux2ast
      }
      {
        package: ast_pkg
        struct: ast_vx_supp
        domain: Aon
        inter_pd: false
        signame: ast_vx_supp_i
        signame_chip:
        {
          asic: ast_vx_supp
          verilator: ast_vx_supp
          cw340: ast_vx_supp
        }
        width: 1
        type: uni
        default: ""
        direction: in
        conn_type: false
        index: -1
        netname: ast_vx_supp
      }
      {
        package: ast_pkg
        struct: ast_obs_bus
        domain: Aon
        inter_pd: false
        signame: ast_obs_i
        signame_chip:
        {
          asic: ast_obs
          verilator: ast_obs
          cw340: ast_obs
        }
        width: 1
        type: uni
        default: ""
        direction: in
        conn_type: false
        index: -1
        netname: ast_obs
      }
      {
        package: ast_pkg
        struct: awire
        domain: Aon
        inter_pd: false
        signame: ast_adc_a0_a_i
        signame_chip:
        {
          asic: ast_adc_a0_a
          verilator: ast_adc_a0_a
          cw340: ast_adc_a0_a
        }
        width: 1
        type: uni
        default: ""
        direction: in
        conn_type: false
        index: -1
        netname: ast_adc_a0_a
      }
      {
        package: ast_pkg
        struct: awire
        domain: Aon
        inter_pd: false
        signame: ast_adc_a1_a_i
        signame_chip:
        {
          asic: ast_adc_a1_a
          verilator: ast_adc_a1_a
          cw340: ast_adc_a1_a
        }
        width: 1
        type: uni
        default: ""
        direction: in
        conn_type: false
        index: -1
        netname: ast_adc_a1_a
      }
      {
        package: ast_pkg
        struct: awire
        domain: Aon
        inter_pd: false
        signame: ast2pad_t0_a_o
        signame_chip:
        {
          asic: ast2pad_t0_a
          verilator: ast2pad_t0_a
          cw340: ast2pad_t0_a
        }
        width: 1
        type: uni
        default: ""
        direction: out
        conn_type: false
        index: -1
        netname: ast2pad_t0_a
      }
      {
        package: ast_pkg
        struct: awire
        domain: Aon
        inter_pd: false
        signame: ast2pad_t1_a_o
        signame_chip:
        {
          asic: ast2pad_t1_a
          verilator: ast2pad_t1_a
          cw340: ast2pad_t1_a
        }
        width: 1
        type: uni
        default: ""
        direction: out
        conn_type: false
        index: -1
        netname: ast2pad_t1_a
      }
      {
        package: ast_pkg
        struct: clks_osc_byp
        domain: Main
        inter_pd: false
        signame: clks_osc_byp_i
        signame_chip:
        {
          asic: clks_osc_byp
          verilator: clks_osc_byp
          cw340: clks_osc_byp
        }
        width: 1
        type: uni
        default: ""
        direction: in
        conn_type: true
        index: -1
        netname: ast_clk_osc_byp
      }
      {
        package: ast_pkg
        struct: ast_pwst
        domain: Aon
        inter_pd: false
        signame: ast_pwst_h_o
        signame_chip:
        {
          asic: ast_pwst_h
          verilator: ast_pwst_h
          cw340: ast_pwst_h
        }
        width: 1
        type: uni
        default: ""
        direction: out
        conn_type: false
        index: -1
        netname: ast_pwst_h
      }
      {
        package: ""
        struct: logic
        domain: Aon
        inter_pd: false
        signame: dft_hold_tap_sel_i
        signame_chip:
        {
          asic: "'0"
          verilator: "'0"
          cw340: "'0"
        }
        width: 1
        type: uni
        default: "'0"
        direction: in
        conn_type: false
        index: -1
        netname: dft_hold_tap_sel
      }
      {
        package: ""
        struct: logic
        domain: Aon
        inter_pd: false
        signame: usb_dp_pullup_en_o
        signame_chip:
        {
          asic: usb_dp_pullup_en
          verilator: usb_dp_pullup_en
          cw340: usb_dp_pullup_en
        }
        width: 1
        type: uni
        default: 1'b0
        direction: out
        conn_type: false
        index: -1
        netname: usb_dp_pullup_en
      }
      {
        package: ""
        struct: logic
        domain: Aon
        inter_pd: false
        signame: usb_dn_pullup_en_o
        signame_chip:
        {
          asic: usb_dn_pullup_en
          verilator: usb_dn_pullup_en
          cw340: ""
        }
        width: 1
        type: uni
        default: 1'b0
        direction: out
        conn_type: false
        index: -1
        netname: usb_dn_pullup_en
      }
      {
        package: ""
        struct: ""
        domain: Main
        inter_pd: false
        signame: rram_test_analog_io
        signame_chip:
        {
          asic: RRAM_ANALOG
          verilator: ""
          cw340: "'0"
        }
        width: 1
        type: io
        default: "'0"
        direction: inout
        conn_type: false
        index: -1
        netname: rram_test_analog
      }
      {
        package: prim_pad_wrapper_pkg
        struct: pad_attr
        domain: Aon
        inter_pd: false
        signame: sensor_ctrl_manual_pad_attr_o
        signame_chip:
        {
          asic: sensor_ctrl_manual_pad_attr
          verilator: ""
          cw340: ""
        }
        width: 4
        type: uni
        default: "'0"
        direction: out
        conn_type: false
        index: -1
        netname: sensor_ctrl_manual_pad_attr
      }
      {
        package: ""
        struct: logic
        domain: Main
        inter_pd: false
        signame: usbdev_usb_rx_d_i
        signame_chip:
        {
          asic: usb_rx_d
          verilator: usb_rx_d
          cw340: usb_rx_d
        }
        width: 1
        type: uni
        default: ""
        direction: in
        conn_type: false
        index: -1
        netname: usbdev_usb_rx_d
      }
      {
        package: ""
        struct: logic
        domain: Main
        inter_pd: false
        signame: usbdev_usb_tx_d_o
        signame_chip:
        {
          asic: ""
          verilator: usb_tx_d
          cw340: ""
        }
        width: 1
        type: uni
        default: ""
        direction: out
        conn_type: false
        index: -1
        netname: usbdev_usb_tx_d
      }
      {
        package: ""
        struct: logic
        domain: Main
        inter_pd: false
        signame: usbdev_usb_tx_se0_o
        signame_chip:
        {
          asic: ""
          verilator: usb_tx_se0
          cw340: ""
        }
        width: 1
        type: uni
        default: ""
        direction: out
        conn_type: false
        index: -1
        netname: usbdev_usb_tx_se0
      }
      {
        package: ""
        struct: logic
        domain: Main
        inter_pd: false
        signame: usbdev_usb_tx_use_d_se0_o
        signame_chip:
        {
          asic: ""
          verilator: usb_tx_use_d_se0
          cw340: ""
        }
        width: 1
        type: uni
        default: ""
        direction: out
        conn_type: false
        index: -1
        netname: usbdev_usb_tx_use_d_se0
      }
      {
        package: ""
        struct: logic
        domain: Main
        inter_pd: false
        signame: usbdev_usb_rx_enable_o
        signame_chip:
        {
          asic: usb_rx_enable
          verilator: usb_rx_enable
          cw340: usb_rx_enable
        }
        width: 1
        type: uni
        default: ""
        direction: out
        conn_type: false
        index: -1
        netname: usbdev_usb_rx_enable
      }
      {
        package: ""
        struct: logic
        domain: Main
        inter_pd: true
        signame: cio_uart0_rx_p2d_i
        signame_chip:
        {
          asic: cio_uart0_rx_p2d
          verilator: cio_uart0_rx_p2d
          cw340: cio_uart0_rx_p2d
        }
        width: 1
        type: uni
        default: "'0"
        direction: in
        conn_type: false
        index: -1
        netname: cio_uart0_rx_p2d
      }
      {
        package: ""
        struct: logic
        domain: Aon
        inter_pd: true
        signame: cio_uart0_rx_p2d_o
        signame_chip:
        {
          asic: cio_uart0_rx_p2d
          verilator: cio_uart0_rx_p2d
          cw340: cio_uart0_rx_p2d
        }
        width: 1
        type: uni
        default: "'0"
        direction: out
        conn_type: false
        index: -1
        netname: cio_uart0_rx_p2d
      }
      {
        package: ""
        struct: logic
        domain: Main
        inter_pd: true
        signame: cio_uart0_tx_d2p_o
        signame_chip:
        {
          asic: cio_uart0_tx_d2p
          verilator: cio_uart0_tx_d2p
          cw340: cio_uart0_tx_d2p
        }
        width: 1
        type: uni
        default: "'0"
        direction: out
        conn_type: false
        index: -1
        netname: cio_uart0_tx_d2p
      }
      {
        package: ""
        struct: logic
        domain: Aon
        inter_pd: true
        signame: cio_uart0_tx_d2p_i
        signame_chip:
        {
          asic: cio_uart0_tx_d2p
          verilator: cio_uart0_tx_d2p
          cw340: cio_uart0_tx_d2p
        }
        width: 1
        type: uni
        default: "'0"
        direction: in
        conn_type: false
        index: -1
        netname: cio_uart0_tx_d2p
      }
      {
        package: ""
        struct: logic
        domain: Main
        inter_pd: true
        signame: cio_uart0_tx_en_d2p_o
        signame_chip:
        {
          asic: cio_uart0_tx_en_d2p
          verilator: cio_uart0_tx_en_d2p
          cw340: cio_uart0_tx_en_d2p
        }
        width: 1
        type: uni
        default: "'0"
        direction: out
        conn_type: false
        index: -1
        netname: cio_uart0_tx_en_d2p
      }
      {
        package: ""
        struct: logic
        domain: Aon
        inter_pd: true
        signame: cio_uart0_tx_en_d2p_i
        signame_chip:
        {
          asic: cio_uart0_tx_en_d2p
          verilator: cio_uart0_tx_en_d2p
          cw340: cio_uart0_tx_en_d2p
        }
        width: 1
        type: uni
        default: "'0"
        direction: in
        conn_type: false
        index: -1
        netname: cio_uart0_tx_en_d2p
      }
      {
        package: ""
        struct: logic
        domain: Main
        inter_pd: true
        signame: cio_uart1_rx_p2d_i
        signame_chip:
        {
          asic: cio_uart1_rx_p2d
          verilator: cio_uart1_rx_p2d
          cw340: cio_uart1_rx_p2d
        }
        width: 1
        type: uni
        default: "'0"
        direction: in
        conn_type: false
        index: -1
        netname: cio_uart1_rx_p2d
      }
      {
        package: ""
        struct: logic
        domain: Aon
        inter_pd: true
        signame: cio_uart1_rx_p2d_o
        signame_chip:
        {
          asic: cio_uart1_rx_p2d
          verilator: cio_uart1_rx_p2d
          cw340: cio_uart1_rx_p2d
        }
        width: 1
        type: uni
        default: "'0"
        direction: out
        conn_type: false
        index: -1
        netname: cio_uart1_rx_p2d
      }
      {
        package: ""
        struct: logic
        domain: Main
        inter_pd: true
        signame: cio_uart1_tx_d2p_o
        signame_chip:
        {
          asic: cio_uart1_tx_d2p
          verilator: cio_uart1_tx_d2p
          cw340: cio_uart1_tx_d2p
        }
        width: 1
        type: uni
        default: "'0"
        direction: out
        conn_type: false
        index: -1
        netname: cio_uart1_tx_d2p
      }
      {
        package: ""
        struct: logic
        domain: Aon
        inter_pd: true
        signame: cio_uart1_tx_d2p_i
        signame_chip:
        {
          asic: cio_uart1_tx_d2p
          verilator: cio_uart1_tx_d2p
          cw340: cio_uart1_tx_d2p
        }
        width: 1
        type: uni
        default: "'0"
        direction: in
        conn_type: false
        index: -1
        netname: cio_uart1_tx_d2p
      }
      {
        package: ""
        struct: logic
        domain: Main
        inter_pd: true
        signame: cio_uart1_tx_en_d2p_o
        signame_chip:
        {
          asic: cio_uart1_tx_en_d2p
          verilator: cio_uart1_tx_en_d2p
          cw340: cio_uart1_tx_en_d2p
        }
        width: 1
        type: uni
        default: "'0"
        direction: out
        conn_type: false
        index: -1
        netname: cio_uart1_tx_en_d2p
      }
      {
        package: ""
        struct: logic
        domain: Aon
        inter_pd: true
        signame: cio_uart1_tx_en_d2p_i
        signame_chip:
        {
          asic: cio_uart1_tx_en_d2p
          verilator: cio_uart1_tx_en_d2p
          cw340: cio_uart1_tx_en_d2p
        }
        width: 1
        type: uni
        default: "'0"
        direction: in
        conn_type: false
        index: -1
        netname: cio_uart1_tx_en_d2p
      }
      {
        package: ""
        struct: logic
        domain: Main
        inter_pd: true
        signame: cio_uart2_rx_p2d_i
        signame_chip:
        {
          asic: cio_uart2_rx_p2d
          verilator: cio_uart2_rx_p2d
          cw340: cio_uart2_rx_p2d
        }
        width: 1
        type: uni
        default: "'0"
        direction: in
        conn_type: false
        index: -1
        netname: cio_uart2_rx_p2d
      }
      {
        package: ""
        struct: logic
        domain: Aon
        inter_pd: true
        signame: cio_uart2_rx_p2d_o
        signame_chip:
        {
          asic: cio_uart2_rx_p2d
          verilator: cio_uart2_rx_p2d
          cw340: cio_uart2_rx_p2d
        }
        width: 1
        type: uni
        default: "'0"
        direction: out
        conn_type: false
        index: -1
        netname: cio_uart2_rx_p2d
      }
      {
        package: ""
        struct: logic
        domain: Main
        inter_pd: true
        signame: cio_uart2_tx_d2p_o
        signame_chip:
        {
          asic: cio_uart2_tx_d2p
          verilator: cio_uart2_tx_d2p
          cw340: cio_uart2_tx_d2p
        }
        width: 1
        type: uni
        default: "'0"
        direction: out
        conn_type: false
        index: -1
        netname: cio_uart2_tx_d2p
      }
      {
        package: ""
        struct: logic
        domain: Aon
        inter_pd: true
        signame: cio_uart2_tx_d2p_i
        signame_chip:
        {
          asic: cio_uart2_tx_d2p
          verilator: cio_uart2_tx_d2p
          cw340: cio_uart2_tx_d2p
        }
        width: 1
        type: uni
        default: "'0"
        direction: in
        conn_type: false
        index: -1
        netname: cio_uart2_tx_d2p
      }
      {
        package: ""
        struct: logic
        domain: Main
        inter_pd: true
        signame: cio_uart2_tx_en_d2p_o
        signame_chip:
        {
          asic: cio_uart2_tx_en_d2p
          verilator: cio_uart2_tx_en_d2p
          cw340: cio_uart2_tx_en_d2p
        }
        width: 1
        type: uni
        default: "'0"
        direction: out
        conn_type: false
        index: -1
        netname: cio_uart2_tx_en_d2p
      }
      {
        package: ""
        struct: logic
        domain: Aon
        inter_pd: true
        signame: cio_uart2_tx_en_d2p_i
        signame_chip:
        {
          asic: cio_uart2_tx_en_d2p
          verilator: cio_uart2_tx_en_d2p
          cw340: cio_uart2_tx_en_d2p
        }
        width: 1
        type: uni
        default: "'0"
        direction: in
        conn_type: false
        index: -1
        netname: cio_uart2_tx_en_d2p
      }
      {
        package: ""
        struct: logic
        domain: Main
        inter_pd: true
        signame: cio_uart3_rx_p2d_i
        signame_chip:
        {
          asic: cio_uart3_rx_p2d
          verilator: cio_uart3_rx_p2d
          cw340: cio_uart3_rx_p2d
        }
        width: 1
        type: uni
        default: "'0"
        direction: in
        conn_type: false
        index: -1
        netname: cio_uart3_rx_p2d
      }
      {
        package: ""
        struct: logic
        domain: Aon
        inter_pd: true
        signame: cio_uart3_rx_p2d_o
        signame_chip:
        {
          asic: cio_uart3_rx_p2d
          verilator: cio_uart3_rx_p2d
          cw340: cio_uart3_rx_p2d
        }
        width: 1
        type: uni
        default: "'0"
        direction: out
        conn_type: false
        index: -1
        netname: cio_uart3_rx_p2d
      }
      {
        package: ""
        struct: logic
        domain: Main
        inter_pd: true
        signame: cio_uart3_tx_d2p_o
        signame_chip:
        {
          asic: cio_uart3_tx_d2p
          verilator: cio_uart3_tx_d2p
          cw340: cio_uart3_tx_d2p
        }
        width: 1
        type: uni
        default: "'0"
        direction: out
        conn_type: false
        index: -1
        netname: cio_uart3_tx_d2p
      }
      {
        package: ""
        struct: logic
        domain: Aon
        inter_pd: true
        signame: cio_uart3_tx_d2p_i
        signame_chip:
        {
          asic: cio_uart3_tx_d2p
          verilator: cio_uart3_tx_d2p
          cw340: cio_uart3_tx_d2p
        }
        width: 1
        type: uni
        default: "'0"
        direction: in
        conn_type: false
        index: -1
        netname: cio_uart3_tx_d2p
      }
      {
        package: ""
        struct: logic
        domain: Main
        inter_pd: true
        signame: cio_uart3_tx_en_d2p_o
        signame_chip:
        {
          asic: cio_uart3_tx_en_d2p
          verilator: cio_uart3_tx_en_d2p
          cw340: cio_uart3_tx_en_d2p
        }
        width: 1
        type: uni
        default: "'0"
        direction: out
        conn_type: false
        index: -1
        netname: cio_uart3_tx_en_d2p
      }
      {
        package: ""
        struct: logic
        domain: Aon
        inter_pd: true
        signame: cio_uart3_tx_en_d2p_i
        signame_chip:
        {
          asic: cio_uart3_tx_en_d2p
          verilator: cio_uart3_tx_en_d2p
          cw340: cio_uart3_tx_en_d2p
        }
        width: 1
        type: uni
        default: "'0"
        direction: in
        conn_type: false
        index: -1
        netname: cio_uart3_tx_en_d2p
      }
      {
        package: ""
        struct: logic
        domain: Main
        inter_pd: true
        signame: cio_gpio0_gpio_d2p_o
        signame_chip:
        {
          asic: cio_gpio0_gpio_d2p
          verilator: cio_gpio0_gpio_d2p
          cw340: cio_gpio0_gpio_d2p
        }
        width: 32
        type: uni
        default: "'0"
        direction: out
        conn_type: false
        index: -1
        netname: cio_gpio0_gpio_d2p
      }
      {
        package: ""
        struct: logic
        domain: Aon
        inter_pd: true
        signame: cio_gpio0_gpio_d2p_i
        signame_chip:
        {
          asic: cio_gpio0_gpio_d2p
          verilator: cio_gpio0_gpio_d2p
          cw340: cio_gpio0_gpio_d2p
        }
        width: 32
        type: uni
        default: "'0"
        direction: in
        conn_type: false
        index: -1
        netname: cio_gpio0_gpio_d2p
      }
      {
        package: ""
        struct: logic
        domain: Main
        inter_pd: true
        signame: cio_gpio0_gpio_en_d2p_o
        signame_chip:
        {
          asic: cio_gpio0_gpio_en_d2p
          verilator: cio_gpio0_gpio_en_d2p
          cw340: cio_gpio0_gpio_en_d2p
        }
        width: 32
        type: uni
        default: "'0"
        direction: out
        conn_type: false
        index: -1
        netname: cio_gpio0_gpio_en_d2p
      }
      {
        package: ""
        struct: logic
        domain: Aon
        inter_pd: true
        signame: cio_gpio0_gpio_en_d2p_i
        signame_chip:
        {
          asic: cio_gpio0_gpio_en_d2p
          verilator: cio_gpio0_gpio_en_d2p
          cw340: cio_gpio0_gpio_en_d2p
        }
        width: 32
        type: uni
        default: "'0"
        direction: in
        conn_type: false
        index: -1
        netname: cio_gpio0_gpio_en_d2p
      }
      {
        package: ""
        struct: logic
        domain: Main
        inter_pd: true
        signame: cio_gpio0_gpio_p2d_i
        signame_chip:
        {
          asic: cio_gpio0_gpio_p2d
          verilator: cio_gpio0_gpio_p2d
          cw340: cio_gpio0_gpio_p2d
        }
        width: 32
        type: uni
        default: "'0"
        direction: in
        conn_type: false
        index: -1
        netname: cio_gpio0_gpio_p2d
      }
      {
        package: ""
        struct: logic
        domain: Aon
        inter_pd: true
        signame: cio_gpio0_gpio_p2d_o
        signame_chip:
        {
          asic: cio_gpio0_gpio_p2d
          verilator: cio_gpio0_gpio_p2d
          cw340: cio_gpio0_gpio_p2d
        }
        width: 32
        type: uni
        default: "'0"
        direction: out
        conn_type: false
        index: -1
        netname: cio_gpio0_gpio_p2d
      }
      {
        package: ""
        struct: logic
        domain: Main
        inter_pd: true
        signame: cio_gpio1_gpio_d2p_o
        signame_chip:
        {
          asic: cio_gpio1_gpio_d2p
          verilator: cio_gpio1_gpio_d2p
          cw340: cio_gpio1_gpio_d2p
        }
        width: 32
        type: uni
        default: "'0"
        direction: out
        conn_type: false
        index: -1
        netname: cio_gpio1_gpio_d2p
      }
      {
        package: ""
        struct: logic
        domain: Aon
        inter_pd: true
        signame: cio_gpio1_gpio_d2p_i
        signame_chip:
        {
          asic: cio_gpio1_gpio_d2p
          verilator: cio_gpio1_gpio_d2p
          cw340: cio_gpio1_gpio_d2p
        }
        width: 32
        type: uni
        default: "'0"
        direction: in
        conn_type: false
        index: -1
        netname: cio_gpio1_gpio_d2p
      }
      {
        package: ""
        struct: logic
        domain: Main
        inter_pd: true
        signame: cio_gpio1_gpio_en_d2p_o
        signame_chip:
        {
          asic: cio_gpio1_gpio_en_d2p
          verilator: cio_gpio1_gpio_en_d2p
          cw340: cio_gpio1_gpio_en_d2p
        }
        width: 32
        type: uni
        default: "'0"
        direction: out
        conn_type: false
        index: -1
        netname: cio_gpio1_gpio_en_d2p
      }
      {
        package: ""
        struct: logic
        domain: Aon
        inter_pd: true
        signame: cio_gpio1_gpio_en_d2p_i
        signame_chip:
        {
          asic: cio_gpio1_gpio_en_d2p
          verilator: cio_gpio1_gpio_en_d2p
          cw340: cio_gpio1_gpio_en_d2p
        }
        width: 32
        type: uni
        default: "'0"
        direction: in
        conn_type: false
        index: -1
        netname: cio_gpio1_gpio_en_d2p
      }
      {
        package: ""
        struct: logic
        domain: Main
        inter_pd: true
        signame: cio_gpio1_gpio_p2d_i
        signame_chip:
        {
          asic: cio_gpio1_gpio_p2d
          verilator: cio_gpio1_gpio_p2d
          cw340: cio_gpio1_gpio_p2d
        }
        width: 32
        type: uni
        default: "'0"
        direction: in
        conn_type: false
        index: -1
        netname: cio_gpio1_gpio_p2d
      }
      {
        package: ""
        struct: logic
        domain: Aon
        inter_pd: true
        signame: cio_gpio1_gpio_p2d_o
        signame_chip:
        {
          asic: cio_gpio1_gpio_p2d
          verilator: cio_gpio1_gpio_p2d
          cw340: cio_gpio1_gpio_p2d
        }
        width: 32
        type: uni
        default: "'0"
        direction: out
        conn_type: false
        index: -1
        netname: cio_gpio1_gpio_p2d
      }
      {
        package: ""
        struct: logic
        domain: Main
        inter_pd: true
        signame: cio_spi_device_sd_d2p_o
        signame_chip:
        {
          asic: cio_spi_device_sd_d2p
          verilator: cio_spi_device_sd_d2p
          cw340: cio_spi_device_sd_d2p
        }
        width: 4
        type: uni
        default: "'0"
        direction: out
        conn_type: false
        index: -1
        netname: cio_spi_device_sd_d2p
      }
      {
        package: ""
        struct: logic
        domain: Aon
        inter_pd: true
        signame: cio_spi_device_sd_d2p_i
        signame_chip:
        {
          asic: cio_spi_device_sd_d2p
          verilator: cio_spi_device_sd_d2p
          cw340: cio_spi_device_sd_d2p
        }
        width: 4
        type: uni
        default: "'0"
        direction: in
        conn_type: false
        index: -1
        netname: cio_spi_device_sd_d2p
      }
      {
        package: ""
        struct: logic
        domain: Main
        inter_pd: true
        signame: cio_spi_device_sd_en_d2p_o
        signame_chip:
        {
          asic: cio_spi_device_sd_en_d2p
          verilator: cio_spi_device_sd_en_d2p
          cw340: cio_spi_device_sd_en_d2p
        }
        width: 4
        type: uni
        default: "'0"
        direction: out
        conn_type: false
        index: -1
        netname: cio_spi_device_sd_en_d2p
      }
      {
        package: ""
        struct: logic
        domain: Aon
        inter_pd: true
        signame: cio_spi_device_sd_en_d2p_i
        signame_chip:
        {
          asic: cio_spi_device_sd_en_d2p
          verilator: cio_spi_device_sd_en_d2p
          cw340: cio_spi_device_sd_en_d2p
        }
        width: 4
        type: uni
        default: "'0"
        direction: in
        conn_type: false
        index: -1
        netname: cio_spi_device_sd_en_d2p
      }
      {
        package: ""
        struct: logic
        domain: Main
        inter_pd: true
        signame: cio_spi_device_sd_p2d_i
        signame_chip:
        {
          asic: cio_spi_device_sd_p2d
          verilator: cio_spi_device_sd_p2d
          cw340: cio_spi_device_sd_p2d
        }
        width: 4
        type: uni
        default: "'0"
        direction: in
        conn_type: false
        index: -1
        netname: cio_spi_device_sd_p2d
      }
      {
        package: ""
        struct: logic
        domain: Aon
        inter_pd: true
        signame: cio_spi_device_sd_p2d_o
        signame_chip:
        {
          asic: cio_spi_device_sd_p2d
          verilator: cio_spi_device_sd_p2d
          cw340: cio_spi_device_sd_p2d
        }
        width: 4
        type: uni
        default: "'0"
        direction: out
        conn_type: false
        index: -1
        netname: cio_spi_device_sd_p2d
      }
      {
        package: ""
        struct: logic
        domain: Main
        inter_pd: true
        signame: cio_spi_device_sck_p2d_i
        signame_chip:
        {
          asic: cio_spi_device_sck_p2d
          verilator: cio_spi_device_sck_p2d
          cw340: cio_spi_device_sck_p2d
        }
        width: 1
        type: uni
        default: "'0"
        direction: in
        conn_type: false
        index: -1
        netname: cio_spi_device_sck_p2d
      }
      {
        package: ""
        struct: logic
        domain: Aon
        inter_pd: true
        signame: cio_spi_device_sck_p2d_o
        signame_chip:
        {
          asic: cio_spi_device_sck_p2d
          verilator: cio_spi_device_sck_p2d
          cw340: cio_spi_device_sck_p2d
        }
        width: 1
        type: uni
        default: "'0"
        direction: out
        conn_type: false
        index: -1
        netname: cio_spi_device_sck_p2d
      }
      {
        package: ""
        struct: logic
        domain: Main
        inter_pd: true
        signame: cio_spi_device_csb_p2d_i
        signame_chip:
        {
          asic: cio_spi_device_csb_p2d
          verilator: cio_spi_device_csb_p2d
          cw340: cio_spi_device_csb_p2d
        }
        width: 1
        type: uni
        default: "'0"
        direction: in
        conn_type: false
        index: -1
        netname: cio_spi_device_csb_p2d
      }
      {
        package: ""
        struct: logic
        domain: Aon
        inter_pd: true
        signame: cio_spi_device_csb_p2d_o
        signame_chip:
        {
          asic: cio_spi_device_csb_p2d
          verilator: cio_spi_device_csb_p2d
          cw340: cio_spi_device_csb_p2d
        }
        width: 1
        type: uni
        default: "'0"
        direction: out
        conn_type: false
        index: -1
        netname: cio_spi_device_csb_p2d
      }
      {
        package: ""
        struct: logic
        domain: Main
        inter_pd: true
        signame: cio_spi_device_tpm_csb_p2d_i
        signame_chip:
        {
          asic: cio_spi_device_tpm_csb_p2d
          verilator: cio_spi_device_tpm_csb_p2d
          cw340: cio_spi_device_tpm_csb_p2d
        }
        width: 1
        type: uni
        default: "'0"
        direction: in
        conn_type: false
        index: -1
        netname: cio_spi_device_tpm_csb_p2d
      }
      {
        package: ""
        struct: logic
        domain: Aon
        inter_pd: true
        signame: cio_spi_device_tpm_csb_p2d_o
        signame_chip:
        {
          asic: cio_spi_device_tpm_csb_p2d
          verilator: cio_spi_device_tpm_csb_p2d
          cw340: cio_spi_device_tpm_csb_p2d
        }
        width: 1
        type: uni
        default: "'0"
        direction: out
        conn_type: false
        index: -1
        netname: cio_spi_device_tpm_csb_p2d
      }
      {
        package: ""
        struct: logic
        domain: Main
        inter_pd: true
        signame: cio_i2c0_sda_d2p_o
        signame_chip:
        {
          asic: cio_i2c0_sda_d2p
          verilator: cio_i2c0_sda_d2p
          cw340: cio_i2c0_sda_d2p
        }
        width: 1
        type: uni
        default: "'0"
        direction: out
        conn_type: false
        index: -1
        netname: cio_i2c0_sda_d2p
      }
      {
        package: ""
        struct: logic
        domain: Aon
        inter_pd: true
        signame: cio_i2c0_sda_d2p_i
        signame_chip:
        {
          asic: cio_i2c0_sda_d2p
          verilator: cio_i2c0_sda_d2p
          cw340: cio_i2c0_sda_d2p
        }
        width: 1
        type: uni
        default: "'0"
        direction: in
        conn_type: false
        index: -1
        netname: cio_i2c0_sda_d2p
      }
      {
        package: ""
        struct: logic
        domain: Main
        inter_pd: true
        signame: cio_i2c0_sda_en_d2p_o
        signame_chip:
        {
          asic: cio_i2c0_sda_en_d2p
          verilator: cio_i2c0_sda_en_d2p
          cw340: cio_i2c0_sda_en_d2p
        }
        width: 1
        type: uni
        default: "'0"
        direction: out
        conn_type: false
        index: -1
        netname: cio_i2c0_sda_en_d2p
      }
      {
        package: ""
        struct: logic
        domain: Aon
        inter_pd: true
        signame: cio_i2c0_sda_en_d2p_i
        signame_chip:
        {
          asic: cio_i2c0_sda_en_d2p
          verilator: cio_i2c0_sda_en_d2p
          cw340: cio_i2c0_sda_en_d2p
        }
        width: 1
        type: uni
        default: "'0"
        direction: in
        conn_type: false
        index: -1
        netname: cio_i2c0_sda_en_d2p
      }
      {
        package: ""
        struct: logic
        domain: Main
        inter_pd: true
        signame: cio_i2c0_sda_p2d_i
        signame_chip:
        {
          asic: cio_i2c0_sda_p2d
          verilator: cio_i2c0_sda_p2d
          cw340: cio_i2c0_sda_p2d
        }
        width: 1
        type: uni
        default: "'0"
        direction: in
        conn_type: false
        index: -1
        netname: cio_i2c0_sda_p2d
      }
      {
        package: ""
        struct: logic
        domain: Aon
        inter_pd: true
        signame: cio_i2c0_sda_p2d_o
        signame_chip:
        {
          asic: cio_i2c0_sda_p2d
          verilator: cio_i2c0_sda_p2d
          cw340: cio_i2c0_sda_p2d
        }
        width: 1
        type: uni
        default: "'0"
        direction: out
        conn_type: false
        index: -1
        netname: cio_i2c0_sda_p2d
      }
      {
        package: ""
        struct: logic
        domain: Main
        inter_pd: true
        signame: cio_i2c0_scl_d2p_o
        signame_chip:
        {
          asic: cio_i2c0_scl_d2p
          verilator: cio_i2c0_scl_d2p
          cw340: cio_i2c0_scl_d2p
        }
        width: 1
        type: uni
        default: "'0"
        direction: out
        conn_type: false
        index: -1
        netname: cio_i2c0_scl_d2p
      }
      {
        package: ""
        struct: logic
        domain: Aon
        inter_pd: true
        signame: cio_i2c0_scl_d2p_i
        signame_chip:
        {
          asic: cio_i2c0_scl_d2p
          verilator: cio_i2c0_scl_d2p
          cw340: cio_i2c0_scl_d2p
        }
        width: 1
        type: uni
        default: "'0"
        direction: in
        conn_type: false
        index: -1
        netname: cio_i2c0_scl_d2p
      }
      {
        package: ""
        struct: logic
        domain: Main
        inter_pd: true
        signame: cio_i2c0_scl_en_d2p_o
        signame_chip:
        {
          asic: cio_i2c0_scl_en_d2p
          verilator: cio_i2c0_scl_en_d2p
          cw340: cio_i2c0_scl_en_d2p
        }
        width: 1
        type: uni
        default: "'0"
        direction: out
        conn_type: false
        index: -1
        netname: cio_i2c0_scl_en_d2p
      }
      {
        package: ""
        struct: logic
        domain: Aon
        inter_pd: true
        signame: cio_i2c0_scl_en_d2p_i
        signame_chip:
        {
          asic: cio_i2c0_scl_en_d2p
          verilator: cio_i2c0_scl_en_d2p
          cw340: cio_i2c0_scl_en_d2p
        }
        width: 1
        type: uni
        default: "'0"
        direction: in
        conn_type: false
        index: -1
        netname: cio_i2c0_scl_en_d2p
      }
      {
        package: ""
        struct: logic
        domain: Main
        inter_pd: true
        signame: cio_i2c0_scl_p2d_i
        signame_chip:
        {
          asic: cio_i2c0_scl_p2d
          verilator: cio_i2c0_scl_p2d
          cw340: cio_i2c0_scl_p2d
        }
        width: 1
        type: uni
        default: "'0"
        direction: in
        conn_type: false
        index: -1
        netname: cio_i2c0_scl_p2d
      }
      {
        package: ""
        struct: logic
        domain: Aon
        inter_pd: true
        signame: cio_i2c0_scl_p2d_o
        signame_chip:
        {
          asic: cio_i2c0_scl_p2d
          verilator: cio_i2c0_scl_p2d
          cw340: cio_i2c0_scl_p2d
        }
        width: 1
        type: uni
        default: "'0"
        direction: out
        conn_type: false
        index: -1
        netname: cio_i2c0_scl_p2d
      }
      {
        package: ""
        struct: logic
        domain: Main
        inter_pd: true
        signame: cio_i2c1_sda_d2p_o
        signame_chip:
        {
          asic: cio_i2c1_sda_d2p
          verilator: cio_i2c1_sda_d2p
          cw340: cio_i2c1_sda_d2p
        }
        width: 1
        type: uni
        default: "'0"
        direction: out
        conn_type: false
        index: -1
        netname: cio_i2c1_sda_d2p
      }
      {
        package: ""
        struct: logic
        domain: Aon
        inter_pd: true
        signame: cio_i2c1_sda_d2p_i
        signame_chip:
        {
          asic: cio_i2c1_sda_d2p
          verilator: cio_i2c1_sda_d2p
          cw340: cio_i2c1_sda_d2p
        }
        width: 1
        type: uni
        default: "'0"
        direction: in
        conn_type: false
        index: -1
        netname: cio_i2c1_sda_d2p
      }
      {
        package: ""
        struct: logic
        domain: Main
        inter_pd: true
        signame: cio_i2c1_sda_en_d2p_o
        signame_chip:
        {
          asic: cio_i2c1_sda_en_d2p
          verilator: cio_i2c1_sda_en_d2p
          cw340: cio_i2c1_sda_en_d2p
        }
        width: 1
        type: uni
        default: "'0"
        direction: out
        conn_type: false
        index: -1
        netname: cio_i2c1_sda_en_d2p
      }
      {
        package: ""
        struct: logic
        domain: Aon
        inter_pd: true
        signame: cio_i2c1_sda_en_d2p_i
        signame_chip:
        {
          asic: cio_i2c1_sda_en_d2p
          verilator: cio_i2c1_sda_en_d2p
          cw340: cio_i2c1_sda_en_d2p
        }
        width: 1
        type: uni
        default: "'0"
        direction: in
        conn_type: false
        index: -1
        netname: cio_i2c1_sda_en_d2p
      }
      {
        package: ""
        struct: logic
        domain: Main
        inter_pd: true
        signame: cio_i2c1_sda_p2d_i
        signame_chip:
        {
          asic: cio_i2c1_sda_p2d
          verilator: cio_i2c1_sda_p2d
          cw340: cio_i2c1_sda_p2d
        }
        width: 1
        type: uni
        default: "'0"
        direction: in
        conn_type: false
        index: -1
        netname: cio_i2c1_sda_p2d
      }
      {
        package: ""
        struct: logic
        domain: Aon
        inter_pd: true
        signame: cio_i2c1_sda_p2d_o
        signame_chip:
        {
          asic: cio_i2c1_sda_p2d
          verilator: cio_i2c1_sda_p2d
          cw340: cio_i2c1_sda_p2d
        }
        width: 1
        type: uni
        default: "'0"
        direction: out
        conn_type: false
        index: -1
        netname: cio_i2c1_sda_p2d
      }
      {
        package: ""
        struct: logic
        domain: Main
        inter_pd: true
        signame: cio_i2c1_scl_d2p_o
        signame_chip:
        {
          asic: cio_i2c1_scl_d2p
          verilator: cio_i2c1_scl_d2p
          cw340: cio_i2c1_scl_d2p
        }
        width: 1
        type: uni
        default: "'0"
        direction: out
        conn_type: false
        index: -1
        netname: cio_i2c1_scl_d2p
      }
      {
        package: ""
        struct: logic
        domain: Aon
        inter_pd: true
        signame: cio_i2c1_scl_d2p_i
        signame_chip:
        {
          asic: cio_i2c1_scl_d2p
          verilator: cio_i2c1_scl_d2p
          cw340: cio_i2c1_scl_d2p
        }
        width: 1
        type: uni
        default: "'0"
        direction: in
        conn_type: false
        index: -1
        netname: cio_i2c1_scl_d2p
      }
      {
        package: ""
        struct: logic
        domain: Main
        inter_pd: true
        signame: cio_i2c1_scl_en_d2p_o
        signame_chip:
        {
          asic: cio_i2c1_scl_en_d2p
          verilator: cio_i2c1_scl_en_d2p
          cw340: cio_i2c1_scl_en_d2p
        }
        width: 1
        type: uni
        default: "'0"
        direction: out
        conn_type: false
        index: -1
        netname: cio_i2c1_scl_en_d2p
      }
      {
        package: ""
        struct: logic
        domain: Aon
        inter_pd: true
        signame: cio_i2c1_scl_en_d2p_i
        signame_chip:
        {
          asic: cio_i2c1_scl_en_d2p
          verilator: cio_i2c1_scl_en_d2p
          cw340: cio_i2c1_scl_en_d2p
        }
        width: 1
        type: uni
        default: "'0"
        direction: in
        conn_type: false
        index: -1
        netname: cio_i2c1_scl_en_d2p
      }
      {
        package: ""
        struct: logic
        domain: Main
        inter_pd: true
        signame: cio_i2c1_scl_p2d_i
        signame_chip:
        {
          asic: cio_i2c1_scl_p2d
          verilator: cio_i2c1_scl_p2d
          cw340: cio_i2c1_scl_p2d
        }
        width: 1
        type: uni
        default: "'0"
        direction: in
        conn_type: false
        index: -1
        netname: cio_i2c1_scl_p2d
      }
      {
        package: ""
        struct: logic
        domain: Aon
        inter_pd: true
        signame: cio_i2c1_scl_p2d_o
        signame_chip:
        {
          asic: cio_i2c1_scl_p2d
          verilator: cio_i2c1_scl_p2d
          cw340: cio_i2c1_scl_p2d
        }
        width: 1
        type: uni
        default: "'0"
        direction: out
        conn_type: false
        index: -1
        netname: cio_i2c1_scl_p2d
      }
      {
        package: ""
        struct: logic
        domain: Main
        inter_pd: true
        signame: cio_i2c2_sda_d2p_o
        signame_chip:
        {
          asic: cio_i2c2_sda_d2p
          verilator: cio_i2c2_sda_d2p
          cw340: cio_i2c2_sda_d2p
        }
        width: 1
        type: uni
        default: "'0"
        direction: out
        conn_type: false
        index: -1
        netname: cio_i2c2_sda_d2p
      }
      {
        package: ""
        struct: logic
        domain: Aon
        inter_pd: true
        signame: cio_i2c2_sda_d2p_i
        signame_chip:
        {
          asic: cio_i2c2_sda_d2p
          verilator: cio_i2c2_sda_d2p
          cw340: cio_i2c2_sda_d2p
        }
        width: 1
        type: uni
        default: "'0"
        direction: in
        conn_type: false
        index: -1
        netname: cio_i2c2_sda_d2p
      }
      {
        package: ""
        struct: logic
        domain: Main
        inter_pd: true
        signame: cio_i2c2_sda_en_d2p_o
        signame_chip:
        {
          asic: cio_i2c2_sda_en_d2p
          verilator: cio_i2c2_sda_en_d2p
          cw340: cio_i2c2_sda_en_d2p
        }
        width: 1
        type: uni
        default: "'0"
        direction: out
        conn_type: false
        index: -1
        netname: cio_i2c2_sda_en_d2p
      }
      {
        package: ""
        struct: logic
        domain: Aon
        inter_pd: true
        signame: cio_i2c2_sda_en_d2p_i
        signame_chip:
        {
          asic: cio_i2c2_sda_en_d2p
          verilator: cio_i2c2_sda_en_d2p
          cw340: cio_i2c2_sda_en_d2p
        }
        width: 1
        type: uni
        default: "'0"
        direction: in
        conn_type: false
        index: -1
        netname: cio_i2c2_sda_en_d2p
      }
      {
        package: ""
        struct: logic
        domain: Main
        inter_pd: true
        signame: cio_i2c2_sda_p2d_i
        signame_chip:
        {
          asic: cio_i2c2_sda_p2d
          verilator: cio_i2c2_sda_p2d
          cw340: cio_i2c2_sda_p2d
        }
        width: 1
        type: uni
        default: "'0"
        direction: in
        conn_type: false
        index: -1
        netname: cio_i2c2_sda_p2d
      }
      {
        package: ""
        struct: logic
        domain: Aon
        inter_pd: true
        signame: cio_i2c2_sda_p2d_o
        signame_chip:
        {
          asic: cio_i2c2_sda_p2d
          verilator: cio_i2c2_sda_p2d
          cw340: cio_i2c2_sda_p2d
        }
        width: 1
        type: uni
        default: "'0"
        direction: out
        conn_type: false
        index: -1
        netname: cio_i2c2_sda_p2d
      }
      {
        package: ""
        struct: logic
        domain: Main
        inter_pd: true
        signame: cio_i2c2_scl_d2p_o
        signame_chip:
        {
          asic: cio_i2c2_scl_d2p
          verilator: cio_i2c2_scl_d2p
          cw340: cio_i2c2_scl_d2p
        }
        width: 1
        type: uni
        default: "'0"
        direction: out
        conn_type: false
        index: -1
        netname: cio_i2c2_scl_d2p
      }
      {
        package: ""
        struct: logic
        domain: Aon
        inter_pd: true
        signame: cio_i2c2_scl_d2p_i
        signame_chip:
        {
          asic: cio_i2c2_scl_d2p
          verilator: cio_i2c2_scl_d2p
          cw340: cio_i2c2_scl_d2p
        }
        width: 1
        type: uni
        default: "'0"
        direction: in
        conn_type: false
        index: -1
        netname: cio_i2c2_scl_d2p
      }
      {
        package: ""
        struct: logic
        domain: Main
        inter_pd: true
        signame: cio_i2c2_scl_en_d2p_o
        signame_chip:
        {
          asic: cio_i2c2_scl_en_d2p
          verilator: cio_i2c2_scl_en_d2p
          cw340: cio_i2c2_scl_en_d2p
        }
        width: 1
        type: uni
        default: "'0"
        direction: out
        conn_type: false
        index: -1
        netname: cio_i2c2_scl_en_d2p
      }
      {
        package: ""
        struct: logic
        domain: Aon
        inter_pd: true
        signame: cio_i2c2_scl_en_d2p_i
        signame_chip:
        {
          asic: cio_i2c2_scl_en_d2p
          verilator: cio_i2c2_scl_en_d2p
          cw340: cio_i2c2_scl_en_d2p
        }
        width: 1
        type: uni
        default: "'0"
        direction: in
        conn_type: false
        index: -1
        netname: cio_i2c2_scl_en_d2p
      }
      {
        package: ""
        struct: logic
        domain: Main
        inter_pd: true
        signame: cio_i2c2_scl_p2d_i
        signame_chip:
        {
          asic: cio_i2c2_scl_p2d
          verilator: cio_i2c2_scl_p2d
          cw340: cio_i2c2_scl_p2d
        }
        width: 1
        type: uni
        default: "'0"
        direction: in
        conn_type: false
        index: -1
        netname: cio_i2c2_scl_p2d
      }
      {
        package: ""
        struct: logic
        domain: Aon
        inter_pd: true
        signame: cio_i2c2_scl_p2d_o
        signame_chip:
        {
          asic: cio_i2c2_scl_p2d
          verilator: cio_i2c2_scl_p2d
          cw340: cio_i2c2_scl_p2d
        }
        width: 1
        type: uni
        default: "'0"
        direction: out
        conn_type: false
        index: -1
        netname: cio_i2c2_scl_p2d
      }
      {
        package: ""
        struct: logic
        domain: Main
        inter_pd: true
        signame: cio_i3c0_scl_d2p_o
        signame_chip:
        {
          asic: cio_i3c0_scl_d2p
          verilator: cio_i3c0_scl_d2p
          cw340: cio_i3c0_scl_d2p
        }
        width: 1
        type: uni
        default: "'0"
        direction: out
        conn_type: false
        index: -1
        netname: cio_i3c0_scl_d2p
      }
      {
        package: ""
        struct: logic
        domain: Aon
        inter_pd: true
        signame: cio_i3c0_scl_d2p_i
        signame_chip:
        {
          asic: cio_i3c0_scl_d2p
          verilator: cio_i3c0_scl_d2p
          cw340: cio_i3c0_scl_d2p
        }
        width: 1
        type: uni
        default: "'0"
        direction: in
        conn_type: false
        index: -1
        netname: cio_i3c0_scl_d2p
      }
      {
        package: ""
        struct: logic
        domain: Main
        inter_pd: true
        signame: cio_i3c0_scl_en_d2p_o
        signame_chip:
        {
          asic: cio_i3c0_scl_en_d2p
          verilator: cio_i3c0_scl_en_d2p
          cw340: cio_i3c0_scl_en_d2p
        }
        width: 1
        type: uni
        default: "'0"
        direction: out
        conn_type: false
        index: -1
        netname: cio_i3c0_scl_en_d2p
      }
      {
        package: ""
        struct: logic
        domain: Aon
        inter_pd: true
        signame: cio_i3c0_scl_en_d2p_i
        signame_chip:
        {
          asic: cio_i3c0_scl_en_d2p
          verilator: cio_i3c0_scl_en_d2p
          cw340: cio_i3c0_scl_en_d2p
        }
        width: 1
        type: uni
        default: "'0"
        direction: in
        conn_type: false
        index: -1
        netname: cio_i3c0_scl_en_d2p
      }
      {
        package: ""
        struct: logic
        domain: Main
        inter_pd: true
        signame: cio_i3c0_scl_p2d_i
        signame_chip:
        {
          asic: cio_i3c0_scl_p2d
          verilator: cio_i3c0_scl_p2d
          cw340: cio_i3c0_scl_p2d
        }
        width: 1
        type: uni
        default: "'0"
        direction: in
        conn_type: false
        index: -1
        netname: cio_i3c0_scl_p2d
      }
      {
        package: ""
        struct: logic
        domain: Aon
        inter_pd: true
        signame: cio_i3c0_scl_p2d_o
        signame_chip:
        {
          asic: cio_i3c0_scl_p2d
          verilator: cio_i3c0_scl_p2d
          cw340: cio_i3c0_scl_p2d
        }
        width: 1
        type: uni
        default: "'0"
        direction: out
        conn_type: false
        index: -1
        netname: cio_i3c0_scl_p2d
      }
      {
        package: ""
        struct: logic
        domain: Main
        inter_pd: true
        signame: cio_i3c0_sda_d2p_o
        signame_chip:
        {
          asic: cio_i3c0_sda_d2p
          verilator: cio_i3c0_sda_d2p
          cw340: cio_i3c0_sda_d2p
        }
        width: 1
        type: uni
        default: "'0"
        direction: out
        conn_type: false
        index: -1
        netname: cio_i3c0_sda_d2p
      }
      {
        package: ""
        struct: logic
        domain: Aon
        inter_pd: true
        signame: cio_i3c0_sda_d2p_i
        signame_chip:
        {
          asic: cio_i3c0_sda_d2p
          verilator: cio_i3c0_sda_d2p
          cw340: cio_i3c0_sda_d2p
        }
        width: 1
        type: uni
        default: "'0"
        direction: in
        conn_type: false
        index: -1
        netname: cio_i3c0_sda_d2p
      }
      {
        package: ""
        struct: logic
        domain: Main
        inter_pd: true
        signame: cio_i3c0_sda_en_d2p_o
        signame_chip:
        {
          asic: cio_i3c0_sda_en_d2p
          verilator: cio_i3c0_sda_en_d2p
          cw340: cio_i3c0_sda_en_d2p
        }
        width: 1
        type: uni
        default: "'0"
        direction: out
        conn_type: false
        index: -1
        netname: cio_i3c0_sda_en_d2p
      }
      {
        package: ""
        struct: logic
        domain: Aon
        inter_pd: true
        signame: cio_i3c0_sda_en_d2p_i
        signame_chip:
        {
          asic: cio_i3c0_sda_en_d2p
          verilator: cio_i3c0_sda_en_d2p
          cw340: cio_i3c0_sda_en_d2p
        }
        width: 1
        type: uni
        default: "'0"
        direction: in
        conn_type: false
        index: -1
        netname: cio_i3c0_sda_en_d2p
      }
      {
        package: ""
        struct: logic
        domain: Main
        inter_pd: true
        signame: cio_i3c0_sda_p2d_i
        signame_chip:
        {
          asic: cio_i3c0_sda_p2d
          verilator: cio_i3c0_sda_p2d
          cw340: cio_i3c0_sda_p2d
        }
        width: 1
        type: uni
        default: "'0"
        direction: in
        conn_type: false
        index: -1
        netname: cio_i3c0_sda_p2d
      }
      {
        package: ""
        struct: logic
        domain: Aon
        inter_pd: true
        signame: cio_i3c0_sda_p2d_o
        signame_chip:
        {
          asic: cio_i3c0_sda_p2d
          verilator: cio_i3c0_sda_p2d
          cw340: cio_i3c0_sda_p2d
        }
        width: 1
        type: uni
        default: "'0"
        direction: out
        conn_type: false
        index: -1
        netname: cio_i3c0_sda_p2d
      }
      {
        package: ""
        struct: logic
        domain: Main
        inter_pd: true
        signame: cio_i3c0_ctrl_sda_pu_d2p_o
        signame_chip:
        {
          asic: cio_i3c0_ctrl_sda_pu_d2p
          verilator: cio_i3c0_ctrl_sda_pu_d2p
          cw340: cio_i3c0_ctrl_sda_pu_d2p
        }
        width: 1
        type: uni
        default: "'0"
        direction: out
        conn_type: false
        index: -1
        netname: cio_i3c0_ctrl_sda_pu_d2p
      }
      {
        package: ""
        struct: logic
        domain: Aon
        inter_pd: true
        signame: cio_i3c0_ctrl_sda_pu_d2p_i
        signame_chip:
        {
          asic: cio_i3c0_ctrl_sda_pu_d2p
          verilator: cio_i3c0_ctrl_sda_pu_d2p
          cw340: cio_i3c0_ctrl_sda_pu_d2p
        }
        width: 1
        type: uni
        default: "'0"
        direction: in
        conn_type: false
        index: -1
        netname: cio_i3c0_ctrl_sda_pu_d2p
      }
      {
        package: ""
        struct: logic
        domain: Main
        inter_pd: true
        signame: cio_i3c0_ctrl_sda_pu_en_d2p_o
        signame_chip:
        {
          asic: cio_i3c0_ctrl_sda_pu_en_d2p
          verilator: cio_i3c0_ctrl_sda_pu_en_d2p
          cw340: cio_i3c0_ctrl_sda_pu_en_d2p
        }
        width: 1
        type: uni
        default: "'0"
        direction: out
        conn_type: false
        index: -1
        netname: cio_i3c0_ctrl_sda_pu_en_d2p
      }
      {
        package: ""
        struct: logic
        domain: Aon
        inter_pd: true
        signame: cio_i3c0_ctrl_sda_pu_en_d2p_i
        signame_chip:
        {
          asic: cio_i3c0_ctrl_sda_pu_en_d2p
          verilator: cio_i3c0_ctrl_sda_pu_en_d2p
          cw340: cio_i3c0_ctrl_sda_pu_en_d2p
        }
        width: 1
        type: uni
        default: "'0"
        direction: in
        conn_type: false
        index: -1
        netname: cio_i3c0_ctrl_sda_pu_en_d2p
      }
      {
        package: ""
        struct: logic
        domain: Main
        inter_pd: true
        signame: cio_i3c1_scl_d2p_o
        signame_chip:
        {
          asic: cio_i3c1_scl_d2p
          verilator: cio_i3c1_scl_d2p
          cw340: cio_i3c1_scl_d2p
        }
        width: 1
        type: uni
        default: "'0"
        direction: out
        conn_type: false
        index: -1
        netname: cio_i3c1_scl_d2p
      }
      {
        package: ""
        struct: logic
        domain: Aon
        inter_pd: true
        signame: cio_i3c1_scl_d2p_i
        signame_chip:
        {
          asic: cio_i3c1_scl_d2p
          verilator: cio_i3c1_scl_d2p
          cw340: cio_i3c1_scl_d2p
        }
        width: 1
        type: uni
        default: "'0"
        direction: in
        conn_type: false
        index: -1
        netname: cio_i3c1_scl_d2p
      }
      {
        package: ""
        struct: logic
        domain: Main
        inter_pd: true
        signame: cio_i3c1_scl_en_d2p_o
        signame_chip:
        {
          asic: cio_i3c1_scl_en_d2p
          verilator: cio_i3c1_scl_en_d2p
          cw340: cio_i3c1_scl_en_d2p
        }
        width: 1
        type: uni
        default: "'0"
        direction: out
        conn_type: false
        index: -1
        netname: cio_i3c1_scl_en_d2p
      }
      {
        package: ""
        struct: logic
        domain: Aon
        inter_pd: true
        signame: cio_i3c1_scl_en_d2p_i
        signame_chip:
        {
          asic: cio_i3c1_scl_en_d2p
          verilator: cio_i3c1_scl_en_d2p
          cw340: cio_i3c1_scl_en_d2p
        }
        width: 1
        type: uni
        default: "'0"
        direction: in
        conn_type: false
        index: -1
        netname: cio_i3c1_scl_en_d2p
      }
      {
        package: ""
        struct: logic
        domain: Main
        inter_pd: true
        signame: cio_i3c1_scl_p2d_i
        signame_chip:
        {
          asic: cio_i3c1_scl_p2d
          verilator: cio_i3c1_scl_p2d
          cw340: cio_i3c1_scl_p2d
        }
        width: 1
        type: uni
        default: "'0"
        direction: in
        conn_type: false
        index: -1
        netname: cio_i3c1_scl_p2d
      }
      {
        package: ""
        struct: logic
        domain: Aon
        inter_pd: true
        signame: cio_i3c1_scl_p2d_o
        signame_chip:
        {
          asic: cio_i3c1_scl_p2d
          verilator: cio_i3c1_scl_p2d
          cw340: cio_i3c1_scl_p2d
        }
        width: 1
        type: uni
        default: "'0"
        direction: out
        conn_type: false
        index: -1
        netname: cio_i3c1_scl_p2d
      }
      {
        package: ""
        struct: logic
        domain: Main
        inter_pd: true
        signame: cio_i3c1_sda_d2p_o
        signame_chip:
        {
          asic: cio_i3c1_sda_d2p
          verilator: cio_i3c1_sda_d2p
          cw340: cio_i3c1_sda_d2p
        }
        width: 1
        type: uni
        default: "'0"
        direction: out
        conn_type: false
        index: -1
        netname: cio_i3c1_sda_d2p
      }
      {
        package: ""
        struct: logic
        domain: Aon
        inter_pd: true
        signame: cio_i3c1_sda_d2p_i
        signame_chip:
        {
          asic: cio_i3c1_sda_d2p
          verilator: cio_i3c1_sda_d2p
          cw340: cio_i3c1_sda_d2p
        }
        width: 1
        type: uni
        default: "'0"
        direction: in
        conn_type: false
        index: -1
        netname: cio_i3c1_sda_d2p
      }
      {
        package: ""
        struct: logic
        domain: Main
        inter_pd: true
        signame: cio_i3c1_sda_en_d2p_o
        signame_chip:
        {
          asic: cio_i3c1_sda_en_d2p
          verilator: cio_i3c1_sda_en_d2p
          cw340: cio_i3c1_sda_en_d2p
        }
        width: 1
        type: uni
        default: "'0"
        direction: out
        conn_type: false
        index: -1
        netname: cio_i3c1_sda_en_d2p
      }
      {
        package: ""
        struct: logic
        domain: Aon
        inter_pd: true
        signame: cio_i3c1_sda_en_d2p_i
        signame_chip:
        {
          asic: cio_i3c1_sda_en_d2p
          verilator: cio_i3c1_sda_en_d2p
          cw340: cio_i3c1_sda_en_d2p
        }
        width: 1
        type: uni
        default: "'0"
        direction: in
        conn_type: false
        index: -1
        netname: cio_i3c1_sda_en_d2p
      }
      {
        package: ""
        struct: logic
        domain: Main
        inter_pd: true
        signame: cio_i3c1_sda_p2d_i
        signame_chip:
        {
          asic: cio_i3c1_sda_p2d
          verilator: cio_i3c1_sda_p2d
          cw340: cio_i3c1_sda_p2d
        }
        width: 1
        type: uni
        default: "'0"
        direction: in
        conn_type: false
        index: -1
        netname: cio_i3c1_sda_p2d
      }
      {
        package: ""
        struct: logic
        domain: Aon
        inter_pd: true
        signame: cio_i3c1_sda_p2d_o
        signame_chip:
        {
          asic: cio_i3c1_sda_p2d
          verilator: cio_i3c1_sda_p2d
          cw340: cio_i3c1_sda_p2d
        }
        width: 1
        type: uni
        default: "'0"
        direction: out
        conn_type: false
        index: -1
        netname: cio_i3c1_sda_p2d
      }
      {
        package: ""
        struct: logic
        domain: Main
        inter_pd: true
        signame: cio_i3c1_rstdet_scl_p2d_i
        signame_chip:
        {
          asic: cio_i3c1_rstdet_scl_p2d
          verilator: cio_i3c1_rstdet_scl_p2d
          cw340: cio_i3c1_rstdet_scl_p2d
        }
        width: 1
        type: uni
        default: "'0"
        direction: in
        conn_type: false
        index: -1
        netname: cio_i3c1_rstdet_scl_p2d
      }
      {
        package: ""
        struct: logic
        domain: Aon
        inter_pd: true
        signame: cio_i3c1_rstdet_scl_p2d_o
        signame_chip:
        {
          asic: cio_i3c1_rstdet_scl_p2d
          verilator: cio_i3c1_rstdet_scl_p2d
          cw340: cio_i3c1_rstdet_scl_p2d
        }
        width: 1
        type: uni
        default: "'0"
        direction: out
        conn_type: false
        index: -1
        netname: cio_i3c1_rstdet_scl_p2d
      }
      {
        package: ""
        struct: logic
        domain: Main
        inter_pd: true
        signame: cio_i3c1_rstdet_sda_p2d_i
        signame_chip:
        {
          asic: cio_i3c1_rstdet_sda_p2d
          verilator: cio_i3c1_rstdet_sda_p2d
          cw340: cio_i3c1_rstdet_sda_p2d
        }
        width: 1
        type: uni
        default: "'0"
        direction: in
        conn_type: false
        index: -1
        netname: cio_i3c1_rstdet_sda_p2d
      }
      {
        package: ""
        struct: logic
        domain: Aon
        inter_pd: true
        signame: cio_i3c1_rstdet_sda_p2d_o
        signame_chip:
        {
          asic: cio_i3c1_rstdet_sda_p2d
          verilator: cio_i3c1_rstdet_sda_p2d
          cw340: cio_i3c1_rstdet_sda_p2d
        }
        width: 1
        type: uni
        default: "'0"
        direction: out
        conn_type: false
        index: -1
        netname: cio_i3c1_rstdet_sda_p2d
      }
      {
        package: ""
        struct: logic
        domain: Main
        inter_pd: true
        signame: cio_i3c1_ctrl_sda_pu_d2p_o
        signame_chip:
        {
          asic: cio_i3c1_ctrl_sda_pu_d2p
          verilator: cio_i3c1_ctrl_sda_pu_d2p
          cw340: cio_i3c1_ctrl_sda_pu_d2p
        }
        width: 1
        type: uni
        default: "'0"
        direction: out
        conn_type: false
        index: -1
        netname: cio_i3c1_ctrl_sda_pu_d2p
      }
      {
        package: ""
        struct: logic
        domain: Aon
        inter_pd: true
        signame: cio_i3c1_ctrl_sda_pu_d2p_i
        signame_chip:
        {
          asic: cio_i3c1_ctrl_sda_pu_d2p
          verilator: cio_i3c1_ctrl_sda_pu_d2p
          cw340: cio_i3c1_ctrl_sda_pu_d2p
        }
        width: 1
        type: uni
        default: "'0"
        direction: in
        conn_type: false
        index: -1
        netname: cio_i3c1_ctrl_sda_pu_d2p
      }
      {
        package: ""
        struct: logic
        domain: Main
        inter_pd: true
        signame: cio_i3c1_ctrl_sda_pu_en_d2p_o
        signame_chip:
        {
          asic: cio_i3c1_ctrl_sda_pu_en_d2p
          verilator: cio_i3c1_ctrl_sda_pu_en_d2p
          cw340: cio_i3c1_ctrl_sda_pu_en_d2p
        }
        width: 1
        type: uni
        default: "'0"
        direction: out
        conn_type: false
        index: -1
        netname: cio_i3c1_ctrl_sda_pu_en_d2p
      }
      {
        package: ""
        struct: logic
        domain: Aon
        inter_pd: true
        signame: cio_i3c1_ctrl_sda_pu_en_d2p_i
        signame_chip:
        {
          asic: cio_i3c1_ctrl_sda_pu_en_d2p
          verilator: cio_i3c1_ctrl_sda_pu_en_d2p
          cw340: cio_i3c1_ctrl_sda_pu_en_d2p
        }
        width: 1
        type: uni
        default: "'0"
        direction: in
        conn_type: false
        index: -1
        netname: cio_i3c1_ctrl_sda_pu_en_d2p
      }
      {
        package: ""
        struct: logic
        domain: Main
        inter_pd: true
        signame: cio_spi_host0_sd_d2p_o
        signame_chip:
        {
          asic: cio_spi_host0_sd_d2p
          verilator: cio_spi_host0_sd_d2p
          cw340: cio_spi_host0_sd_d2p
        }
        width: 4
        type: uni
        default: "'0"
        direction: out
        conn_type: false
        index: -1
        netname: cio_spi_host0_sd_d2p
      }
      {
        package: ""
        struct: logic
        domain: Aon
        inter_pd: true
        signame: cio_spi_host0_sd_d2p_i
        signame_chip:
        {
          asic: cio_spi_host0_sd_d2p
          verilator: cio_spi_host0_sd_d2p
          cw340: cio_spi_host0_sd_d2p
        }
        width: 4
        type: uni
        default: "'0"
        direction: in
        conn_type: false
        index: -1
        netname: cio_spi_host0_sd_d2p
      }
      {
        package: ""
        struct: logic
        domain: Main
        inter_pd: true
        signame: cio_spi_host0_sd_en_d2p_o
        signame_chip:
        {
          asic: cio_spi_host0_sd_en_d2p
          verilator: cio_spi_host0_sd_en_d2p
          cw340: cio_spi_host0_sd_en_d2p
        }
        width: 4
        type: uni
        default: "'0"
        direction: out
        conn_type: false
        index: -1
        netname: cio_spi_host0_sd_en_d2p
      }
      {
        package: ""
        struct: logic
        domain: Aon
        inter_pd: true
        signame: cio_spi_host0_sd_en_d2p_i
        signame_chip:
        {
          asic: cio_spi_host0_sd_en_d2p
          verilator: cio_spi_host0_sd_en_d2p
          cw340: cio_spi_host0_sd_en_d2p
        }
        width: 4
        type: uni
        default: "'0"
        direction: in
        conn_type: false
        index: -1
        netname: cio_spi_host0_sd_en_d2p
      }
      {
        package: ""
        struct: logic
        domain: Main
        inter_pd: true
        signame: cio_spi_host0_sd_p2d_i
        signame_chip:
        {
          asic: cio_spi_host0_sd_p2d
          verilator: cio_spi_host0_sd_p2d
          cw340: cio_spi_host0_sd_p2d
        }
        width: 4
        type: uni
        default: "'0"
        direction: in
        conn_type: false
        index: -1
        netname: cio_spi_host0_sd_p2d
      }
      {
        package: ""
        struct: logic
        domain: Aon
        inter_pd: true
        signame: cio_spi_host0_sd_p2d_o
        signame_chip:
        {
          asic: cio_spi_host0_sd_p2d
          verilator: cio_spi_host0_sd_p2d
          cw340: cio_spi_host0_sd_p2d
        }
        width: 4
        type: uni
        default: "'0"
        direction: out
        conn_type: false
        index: -1
        netname: cio_spi_host0_sd_p2d
      }
      {
        package: ""
        struct: logic
        domain: Main
        inter_pd: true
        signame: cio_spi_host0_sck_d2p_o
        signame_chip:
        {
          asic: cio_spi_host0_sck_d2p
          verilator: cio_spi_host0_sck_d2p
          cw340: cio_spi_host0_sck_d2p
        }
        width: 1
        type: uni
        default: "'0"
        direction: out
        conn_type: false
        index: -1
        netname: cio_spi_host0_sck_d2p
      }
      {
        package: ""
        struct: logic
        domain: Aon
        inter_pd: true
        signame: cio_spi_host0_sck_d2p_i
        signame_chip:
        {
          asic: cio_spi_host0_sck_d2p
          verilator: cio_spi_host0_sck_d2p
          cw340: cio_spi_host0_sck_d2p
        }
        width: 1
        type: uni
        default: "'0"
        direction: in
        conn_type: false
        index: -1
        netname: cio_spi_host0_sck_d2p
      }
      {
        package: ""
        struct: logic
        domain: Main
        inter_pd: true
        signame: cio_spi_host0_sck_en_d2p_o
        signame_chip:
        {
          asic: cio_spi_host0_sck_en_d2p
          verilator: cio_spi_host0_sck_en_d2p
          cw340: cio_spi_host0_sck_en_d2p
        }
        width: 1
        type: uni
        default: "'0"
        direction: out
        conn_type: false
        index: -1
        netname: cio_spi_host0_sck_en_d2p
      }
      {
        package: ""
        struct: logic
        domain: Aon
        inter_pd: true
        signame: cio_spi_host0_sck_en_d2p_i
        signame_chip:
        {
          asic: cio_spi_host0_sck_en_d2p
          verilator: cio_spi_host0_sck_en_d2p
          cw340: cio_spi_host0_sck_en_d2p
        }
        width: 1
        type: uni
        default: "'0"
        direction: in
        conn_type: false
        index: -1
        netname: cio_spi_host0_sck_en_d2p
      }
      {
        package: ""
        struct: logic
        domain: Main
        inter_pd: true
        signame: cio_spi_host0_csb_d2p_o
        signame_chip:
        {
          asic: cio_spi_host0_csb_d2p
          verilator: cio_spi_host0_csb_d2p
          cw340: cio_spi_host0_csb_d2p
        }
        width: 3
        type: uni
        default: "'0"
        direction: out
        conn_type: false
        index: -1
        netname: cio_spi_host0_csb_d2p
      }
      {
        package: ""
        struct: logic
        domain: Aon
        inter_pd: true
        signame: cio_spi_host0_csb_d2p_i
        signame_chip:
        {
          asic: cio_spi_host0_csb_d2p
          verilator: cio_spi_host0_csb_d2p
          cw340: cio_spi_host0_csb_d2p
        }
        width: 3
        type: uni
        default: "'0"
        direction: in
        conn_type: false
        index: -1
        netname: cio_spi_host0_csb_d2p
      }
      {
        package: ""
        struct: logic
        domain: Main
        inter_pd: true
        signame: cio_spi_host0_csb_en_d2p_o
        signame_chip:
        {
          asic: cio_spi_host0_csb_en_d2p
          verilator: cio_spi_host0_csb_en_d2p
          cw340: cio_spi_host0_csb_en_d2p
        }
        width: 3
        type: uni
        default: "'0"
        direction: out
        conn_type: false
        index: -1
        netname: cio_spi_host0_csb_en_d2p
      }
      {
        package: ""
        struct: logic
        domain: Aon
        inter_pd: true
        signame: cio_spi_host0_csb_en_d2p_i
        signame_chip:
        {
          asic: cio_spi_host0_csb_en_d2p
          verilator: cio_spi_host0_csb_en_d2p
          cw340: cio_spi_host0_csb_en_d2p
        }
        width: 3
        type: uni
        default: "'0"
        direction: in
        conn_type: false
        index: -1
        netname: cio_spi_host0_csb_en_d2p
      }
      {
        package: ""
        struct: logic
        domain: Main
        inter_pd: true
        signame: cio_spi_host1_sd_d2p_o
        signame_chip:
        {
          asic: cio_spi_host1_sd_d2p
          verilator: cio_spi_host1_sd_d2p
          cw340: cio_spi_host1_sd_d2p
        }
        width: 4
        type: uni
        default: "'0"
        direction: out
        conn_type: false
        index: -1
        netname: cio_spi_host1_sd_d2p
      }
      {
        package: ""
        struct: logic
        domain: Aon
        inter_pd: true
        signame: cio_spi_host1_sd_d2p_i
        signame_chip:
        {
          asic: cio_spi_host1_sd_d2p
          verilator: cio_spi_host1_sd_d2p
          cw340: cio_spi_host1_sd_d2p
        }
        width: 4
        type: uni
        default: "'0"
        direction: in
        conn_type: false
        index: -1
        netname: cio_spi_host1_sd_d2p
      }
      {
        package: ""
        struct: logic
        domain: Main
        inter_pd: true
        signame: cio_spi_host1_sd_en_d2p_o
        signame_chip:
        {
          asic: cio_spi_host1_sd_en_d2p
          verilator: cio_spi_host1_sd_en_d2p
          cw340: cio_spi_host1_sd_en_d2p
        }
        width: 4
        type: uni
        default: "'0"
        direction: out
        conn_type: false
        index: -1
        netname: cio_spi_host1_sd_en_d2p
      }
      {
        package: ""
        struct: logic
        domain: Aon
        inter_pd: true
        signame: cio_spi_host1_sd_en_d2p_i
        signame_chip:
        {
          asic: cio_spi_host1_sd_en_d2p
          verilator: cio_spi_host1_sd_en_d2p
          cw340: cio_spi_host1_sd_en_d2p
        }
        width: 4
        type: uni
        default: "'0"
        direction: in
        conn_type: false
        index: -1
        netname: cio_spi_host1_sd_en_d2p
      }
      {
        package: ""
        struct: logic
        domain: Main
        inter_pd: true
        signame: cio_spi_host1_sd_p2d_i
        signame_chip:
        {
          asic: cio_spi_host1_sd_p2d
          verilator: cio_spi_host1_sd_p2d
          cw340: cio_spi_host1_sd_p2d
        }
        width: 4
        type: uni
        default: "'0"
        direction: in
        conn_type: false
        index: -1
        netname: cio_spi_host1_sd_p2d
      }
      {
        package: ""
        struct: logic
        domain: Aon
        inter_pd: true
        signame: cio_spi_host1_sd_p2d_o
        signame_chip:
        {
          asic: cio_spi_host1_sd_p2d
          verilator: cio_spi_host1_sd_p2d
          cw340: cio_spi_host1_sd_p2d
        }
        width: 4
        type: uni
        default: "'0"
        direction: out
        conn_type: false
        index: -1
        netname: cio_spi_host1_sd_p2d
      }
      {
        package: ""
        struct: logic
        domain: Main
        inter_pd: true
        signame: cio_spi_host1_sck_d2p_o
        signame_chip:
        {
          asic: cio_spi_host1_sck_d2p
          verilator: cio_spi_host1_sck_d2p
          cw340: cio_spi_host1_sck_d2p
        }
        width: 1
        type: uni
        default: "'0"
        direction: out
        conn_type: false
        index: -1
        netname: cio_spi_host1_sck_d2p
      }
      {
        package: ""
        struct: logic
        domain: Aon
        inter_pd: true
        signame: cio_spi_host1_sck_d2p_i
        signame_chip:
        {
          asic: cio_spi_host1_sck_d2p
          verilator: cio_spi_host1_sck_d2p
          cw340: cio_spi_host1_sck_d2p
        }
        width: 1
        type: uni
        default: "'0"
        direction: in
        conn_type: false
        index: -1
        netname: cio_spi_host1_sck_d2p
      }
      {
        package: ""
        struct: logic
        domain: Main
        inter_pd: true
        signame: cio_spi_host1_sck_en_d2p_o
        signame_chip:
        {
          asic: cio_spi_host1_sck_en_d2p
          verilator: cio_spi_host1_sck_en_d2p
          cw340: cio_spi_host1_sck_en_d2p
        }
        width: 1
        type: uni
        default: "'0"
        direction: out
        conn_type: false
        index: -1
        netname: cio_spi_host1_sck_en_d2p
      }
      {
        package: ""
        struct: logic
        domain: Aon
        inter_pd: true
        signame: cio_spi_host1_sck_en_d2p_i
        signame_chip:
        {
          asic: cio_spi_host1_sck_en_d2p
          verilator: cio_spi_host1_sck_en_d2p
          cw340: cio_spi_host1_sck_en_d2p
        }
        width: 1
        type: uni
        default: "'0"
        direction: in
        conn_type: false
        index: -1
        netname: cio_spi_host1_sck_en_d2p
      }
      {
        package: ""
        struct: logic
        domain: Main
        inter_pd: true
        signame: cio_spi_host1_csb_d2p_o
        signame_chip:
        {
          asic: cio_spi_host1_csb_d2p
          verilator: cio_spi_host1_csb_d2p
          cw340: cio_spi_host1_csb_d2p
        }
        width: 3
        type: uni
        default: "'0"
        direction: out
        conn_type: false
        index: -1
        netname: cio_spi_host1_csb_d2p
      }
      {
        package: ""
        struct: logic
        domain: Aon
        inter_pd: true
        signame: cio_spi_host1_csb_d2p_i
        signame_chip:
        {
          asic: cio_spi_host1_csb_d2p
          verilator: cio_spi_host1_csb_d2p
          cw340: cio_spi_host1_csb_d2p
        }
        width: 3
        type: uni
        default: "'0"
        direction: in
        conn_type: false
        index: -1
        netname: cio_spi_host1_csb_d2p
      }
      {
        package: ""
        struct: logic
        domain: Main
        inter_pd: true
        signame: cio_spi_host1_csb_en_d2p_o
        signame_chip:
        {
          asic: cio_spi_host1_csb_en_d2p
          verilator: cio_spi_host1_csb_en_d2p
          cw340: cio_spi_host1_csb_en_d2p
        }
        width: 3
        type: uni
        default: "'0"
        direction: out
        conn_type: false
        index: -1
        netname: cio_spi_host1_csb_en_d2p
      }
      {
        package: ""
        struct: logic
        domain: Aon
        inter_pd: true
        signame: cio_spi_host1_csb_en_d2p_i
        signame_chip:
        {
          asic: cio_spi_host1_csb_en_d2p
          verilator: cio_spi_host1_csb_en_d2p
          cw340: cio_spi_host1_csb_en_d2p
        }
        width: 3
        type: uni
        default: "'0"
        direction: in
        conn_type: false
        index: -1
        netname: cio_spi_host1_csb_en_d2p
      }
      {
        package: ""
        struct: logic
        domain: Main
        inter_pd: true
        signame: cio_usbdev_usb_dp_d2p_o
        signame_chip:
        {
          asic: cio_usbdev_usb_dp_d2p
          verilator: cio_usbdev_usb_dp_d2p
          cw340: cio_usbdev_usb_dp_d2p
        }
        width: 1
        type: uni
        default: "'0"
        direction: out
        conn_type: false
        index: -1
        netname: cio_usbdev_usb_dp_d2p
      }
      {
        package: ""
        struct: logic
        domain: Aon
        inter_pd: true
        signame: cio_usbdev_usb_dp_d2p_i
        signame_chip:
        {
          asic: cio_usbdev_usb_dp_d2p
          verilator: cio_usbdev_usb_dp_d2p
          cw340: cio_usbdev_usb_dp_d2p
        }
        width: 1
        type: uni
        default: "'0"
        direction: in
        conn_type: false
        index: -1
        netname: cio_usbdev_usb_dp_d2p
      }
      {
        package: ""
        struct: logic
        domain: Main
        inter_pd: true
        signame: cio_usbdev_usb_dp_en_d2p_o
        signame_chip:
        {
          asic: cio_usbdev_usb_dp_en_d2p
          verilator: cio_usbdev_usb_dp_en_d2p
          cw340: cio_usbdev_usb_dp_en_d2p
        }
        width: 1
        type: uni
        default: "'0"
        direction: out
        conn_type: false
        index: -1
        netname: cio_usbdev_usb_dp_en_d2p
      }
      {
        package: ""
        struct: logic
        domain: Aon
        inter_pd: true
        signame: cio_usbdev_usb_dp_en_d2p_i
        signame_chip:
        {
          asic: cio_usbdev_usb_dp_en_d2p
          verilator: cio_usbdev_usb_dp_en_d2p
          cw340: cio_usbdev_usb_dp_en_d2p
        }
        width: 1
        type: uni
        default: "'0"
        direction: in
        conn_type: false
        index: -1
        netname: cio_usbdev_usb_dp_en_d2p
      }
      {
        package: ""
        struct: logic
        domain: Main
        inter_pd: true
        signame: cio_usbdev_usb_dp_p2d_i
        signame_chip:
        {
          asic: cio_usbdev_usb_dp_p2d
          verilator: cio_usbdev_usb_dp_p2d
          cw340: cio_usbdev_usb_dp_p2d
        }
        width: 1
        type: uni
        default: "'0"
        direction: in
        conn_type: false
        index: -1
        netname: cio_usbdev_usb_dp_p2d
      }
      {
        package: ""
        struct: logic
        domain: Aon
        inter_pd: true
        signame: cio_usbdev_usb_dp_p2d_o
        signame_chip:
        {
          asic: cio_usbdev_usb_dp_p2d
          verilator: cio_usbdev_usb_dp_p2d
          cw340: cio_usbdev_usb_dp_p2d
        }
        width: 1
        type: uni
        default: "'0"
        direction: out
        conn_type: false
        index: -1
        netname: cio_usbdev_usb_dp_p2d
      }
      {
        package: ""
        struct: logic
        domain: Main
        inter_pd: true
        signame: cio_usbdev_usb_dn_d2p_o
        signame_chip:
        {
          asic: cio_usbdev_usb_dn_d2p
          verilator: cio_usbdev_usb_dn_d2p
          cw340: cio_usbdev_usb_dn_d2p
        }
        width: 1
        type: uni
        default: "'0"
        direction: out
        conn_type: false
        index: -1
        netname: cio_usbdev_usb_dn_d2p
      }
      {
        package: ""
        struct: logic
        domain: Aon
        inter_pd: true
        signame: cio_usbdev_usb_dn_d2p_i
        signame_chip:
        {
          asic: cio_usbdev_usb_dn_d2p
          verilator: cio_usbdev_usb_dn_d2p
          cw340: cio_usbdev_usb_dn_d2p
        }
        width: 1
        type: uni
        default: "'0"
        direction: in
        conn_type: false
        index: -1
        netname: cio_usbdev_usb_dn_d2p
      }
      {
        package: ""
        struct: logic
        domain: Main
        inter_pd: true
        signame: cio_usbdev_usb_dn_en_d2p_o
        signame_chip:
        {
          asic: cio_usbdev_usb_dn_en_d2p
          verilator: cio_usbdev_usb_dn_en_d2p
          cw340: cio_usbdev_usb_dn_en_d2p
        }
        width: 1
        type: uni
        default: "'0"
        direction: out
        conn_type: false
        index: -1
        netname: cio_usbdev_usb_dn_en_d2p
      }
      {
        package: ""
        struct: logic
        domain: Aon
        inter_pd: true
        signame: cio_usbdev_usb_dn_en_d2p_i
        signame_chip:
        {
          asic: cio_usbdev_usb_dn_en_d2p
          verilator: cio_usbdev_usb_dn_en_d2p
          cw340: cio_usbdev_usb_dn_en_d2p
        }
        width: 1
        type: uni
        default: "'0"
        direction: in
        conn_type: false
        index: -1
        netname: cio_usbdev_usb_dn_en_d2p
      }
      {
        package: ""
        struct: logic
        domain: Main
        inter_pd: true
        signame: cio_usbdev_usb_dn_p2d_i
        signame_chip:
        {
          asic: cio_usbdev_usb_dn_p2d
          verilator: cio_usbdev_usb_dn_p2d
          cw340: cio_usbdev_usb_dn_p2d
        }
        width: 1
        type: uni
        default: "'0"
        direction: in
        conn_type: false
        index: -1
        netname: cio_usbdev_usb_dn_p2d
      }
      {
        package: ""
        struct: logic
        domain: Aon
        inter_pd: true
        signame: cio_usbdev_usb_dn_p2d_o
        signame_chip:
        {
          asic: cio_usbdev_usb_dn_p2d
          verilator: cio_usbdev_usb_dn_p2d
          cw340: cio_usbdev_usb_dn_p2d
        }
        width: 1
        type: uni
        default: "'0"
        direction: out
        conn_type: false
        index: -1
        netname: cio_usbdev_usb_dn_p2d
      }
      {
        package: ""
        struct: logic
        domain: Main
        inter_pd: true
        signame: cio_usbdev_sense_p2d_i
        signame_chip:
        {
          asic: cio_usbdev_sense_p2d
          verilator: cio_usbdev_sense_p2d
          cw340: cio_usbdev_sense_p2d
        }
        width: 1
        type: uni
        default: "'0"
        direction: in
        conn_type: false
        index: -1
        netname: cio_usbdev_sense_p2d
      }
      {
        package: ""
        struct: logic
        domain: Aon
        inter_pd: true
        signame: cio_usbdev_sense_p2d_o
        signame_chip:
        {
          asic: cio_usbdev_sense_p2d
          verilator: cio_usbdev_sense_p2d
          cw340: cio_usbdev_sense_p2d
        }
        width: 1
        type: uni
        default: "'0"
        direction: out
        conn_type: false
        index: -1
        netname: cio_usbdev_sense_p2d
      }
      {
        package: ""
        struct: logic
        domain: Main
        inter_pd: true
        signame: ast_clk_src_sys_o
        signame_chip:
        {
          asic: ast_clk_src_sys
          verilator: ast_clk_src_sys
          cw340: ast_clk_src_sys
        }
        width: 1
        type: uni
        default: ""
        direction: out
        conn_type: false
        index: -1
        netname: ast_clk_src_sys
      }
      {
        package: ""
        struct: logic
        domain: Aon
        inter_pd: true
        signame: ast_clk_src_sys_i
        signame_chip:
        {
          asic: ast_clk_src_sys
          verilator: ast_clk_src_sys
          cw340: ast_clk_src_sys
        }
        width: 1
        type: uni
        default: ""
        direction: in
        conn_type: false
        index: -1
        netname: ast_clk_src_sys
      }
      {
        package: ""
        struct: logic
        domain: Main
        inter_pd: true
        signame: ast_clk_src_io_o
        signame_chip:
        {
          asic: ast_clk_src_io
          verilator: ast_clk_src_io
          cw340: ast_clk_src_io
        }
        width: 1
        type: uni
        default: ""
        direction: out
        conn_type: false
        index: -1
        netname: ast_clk_src_io
      }
      {
        package: ""
        struct: logic
        domain: Aon
        inter_pd: true
        signame: ast_clk_src_io_i
        signame_chip:
        {
          asic: ast_clk_src_io
          verilator: ast_clk_src_io
          cw340: ast_clk_src_io
        }
        width: 1
        type: uni
        default: ""
        direction: in
        conn_type: false
        index: -1
        netname: ast_clk_src_io
      }
      {
        package: ""
        struct: logic
        domain: Main
        inter_pd: true
        signame: ast_clk_src_usb_o
        signame_chip:
        {
          asic: ast_clk_src_usb
          verilator: ast_clk_src_usb
          cw340: ast_clk_src_usb
        }
        width: 1
        type: uni
        default: ""
        direction: out
        conn_type: false
        index: -1
        netname: ast_clk_src_usb
      }
      {
        package: ""
        struct: logic
        domain: Aon
        inter_pd: true
        signame: ast_clk_src_usb_i
        signame_chip:
        {
          asic: ast_clk_src_usb
          verilator: ast_clk_src_usb
          cw340: ast_clk_src_usb
        }
        width: 1
        type: uni
        default: ""
        direction: in
        conn_type: false
        index: -1
        netname: ast_clk_src_usb
      }
    ]
    definitions:
    [
      {
        package: ast_pkg
        struct: adc_ast_req
        domain: Aon
        signame: ast_adc_req
        width: 1
        type: req_rsp
        end_idx: -1
        act: rsp
        suffix: req
        default: ast_pkg::ADC_AST_REQ_DEFAULT
      }
      {
        package: ast_pkg
        struct: adc_ast_rsp
        domain: Aon
        signame: ast_adc_rsp
        width: 1
        type: req_rsp
        end_idx: -1
        act: rsp
        suffix: rsp
        default: ""
      }
      {
        package: clkmgr_pkg
        struct: clkmgr_out
        domain: Aon
        signame: ast_sns_clks
        width: 1
        type: uni
        end_idx: -1
        act: rcv
        suffix: ""
        default: clkmgr_pkg::CLKMGR_OUT_DEFAULT
      }
      {
        package: rstmgr_pkg
        struct: rstmgr_out
        domain: Aon
        signame: ast_sns_rsts
        width: 1
        type: uni
        end_idx: -1
        act: rcv
        suffix: ""
        default: rstmgr_pkg::RSTMGR_OUT_DEFAULT
      }
      {
        package: ""
        struct: logic
        domain: Main
        signame: ast_rng_b
        width:
        {
          name: EntropyStreams
          desc: Number of RNG bit streams
          param_type: int unsigned
          unpacked_dimensions: null
          default: 4
          local: true
          expose: true
          name_top: AstEntropyStreams
        }
        type: uni
        end_idx: -1
        act: req
        suffix: ""
        default: "'0"
      }
      {
        package: ""
        struct: logic
        domain: Main
        signame: entropy_src_entropy_src_rng_enable
        width: 1
        type: uni
        end_idx: -1
        act: req
        suffix: ""
        default: 1'b0
      }
      {
        package: ""
        struct: logic
        domain: Main
        signame: entropy_src_rng_fips
        width: 1
        type: uni
        end_idx: -1
        act: req
        suffix: ""
        default: 1'b0
      }
      {
        package: ""
        struct: logic
        domain: Main
        signame: ast_rng_val
        width: 1
        type: uni
        end_idx: -1
        act: req
        suffix: ""
        default: 1'b0
      }
      {
        package: ""
        struct: logic
        domain: Aon
        signame: ast_ast2padmux
        width:
        {
          name: Ast2PadOutWidth
          desc: Width of the DFT AST-to-pad output signal bus
          param_type: int unsigned
          unpacked_dimensions: null
          partition: secondary
          default: 9
          local: true
          expose: true
          name_top: AstAst2PadOutWidth
        }
        type: uni
        end_idx: -1
        act: req
        suffix: ""
        default: "'0"
      }
      {
        package: ast_pkg
        struct: ast_status
        domain: Aon
        signame: ast_io_pwr_st
        width: 1
        type: uni
        end_idx: -1
        act: req
        suffix: ""
        default: ast_pkg::AST_STATUS_DEFAULT
      }
      {
        package: ""
        struct: logic
        domain: Main
        signame: usbdev_usb_ref_pulse
        width: 1
        type: uni
        end_idx: -1
        act: req
        suffix: ""
        default: 1'b0
      }
      {
        package: ""
        struct: logic
        domain: Main
        signame: usbdev_usb_ref_val
        width: 1
        type: uni
        end_idx: -1
        act: req
        suffix: ""
        default: 1'b0
      }
      {
        package: pinmux_pkg
        struct: dft_strap_test_req
        domain: Aon
        signame: pinmux_dft_strap_test
        width: 1
        type: uni
        end_idx: -1
        act: req
        suffix: ""
        default: "'0"
      }
      {
        package: ast_pkg
        struct: ast_alert_req
        domain: Aon
        signame: sensor_ctrl_ast_alert_req
        width: 1
        type: req_rsp
        end_idx: -1
        act: rsp
        suffix: req
        default: ast_pkg::AST_ALERT_REQ_DEFAULT
      }
      {
        package: ast_pkg
        struct: ast_alert_rsp
        domain: Aon
        signame: sensor_ctrl_ast_alert_rsp
        width: 1
        type: req_rsp
        end_idx: -1
        act: rsp
        suffix: rsp
        default: ""
      }
      {
        package: prim_esc_pkg
        struct: esc_rx
        domain: Main
        signame: alert_handler_esc_rx
        width: 4
        type: uni
        end_idx: -1
        act: rcv
        suffix: ""
        default: "'{default: prim_esc_pkg::ESC_RX_DEFAULT}"
      }
      {
        package: prim_esc_pkg
        struct: esc_tx
        domain: Main
        signame: alert_handler_esc_tx
        width: 4
        type: uni
        end_idx: -1
        act: req
        suffix: ""
        default: "'{default: prim_esc_pkg::ESC_TX_DEFAULT}"
      }
      {
        package: csrng_pkg
        struct: csrng_req
        domain: Main
        signame: csrng_csrng_cmd_req
        width: 2
        type: req_rsp
        end_idx: -1
        act: rsp
        suffix: req
        default: "'{default: csrng_pkg::CSRNG_REQ_DEFAULT}"
      }
      {
        package: csrng_pkg
        struct: csrng_rsp
        domain: Main
        signame: csrng_csrng_cmd_rsp
        width: 2
        type: req_rsp
        end_idx: -1
        act: rsp
        suffix: rsp
        default: ""
      }
      {
        package: entropy_src_pkg
        struct: entropy_src_hw_if_req
        domain: Main
        signame: csrng_entropy_src_hw_if_req
        width: 1
        type: req_rsp
        end_idx: -1
        act: req
        suffix: req
        default: ""
      }
      {
        package: entropy_src_pkg
        struct: entropy_src_hw_if_rsp
        domain: Main
        signame: csrng_entropy_src_hw_if_rsp
        width: 1
        type: req_rsp
        end_idx: -1
        act: req
        suffix: rsp
        default: entropy_src_pkg::ENTROPY_SRC_HW_IF_RSP_DEFAULT
      }
      {
        package: otp_ctrl_pkg
        struct: nvm_otp_key_req
        domain: Main
        signame: rram_ctrl_otp_key_req
        width: 1
        type: req_rsp
        end_idx: -1
        act: req
        suffix: req
        default: ""
      }
      {
        package: otp_ctrl_pkg
        struct: nvm_otp_key_rsp
        domain: Main
        signame: rram_ctrl_otp_key_rsp
        width: 1
        type: req_rsp
        end_idx: -1
        act: req
        suffix: rsp
        default: otp_ctrl_pkg::NVM_OTP_KEY_RSP_DEFAULT
      }
      {
        package: lc_ctrl_pkg
        struct: lc_nvm_rma_seed
        domain: Main
        signame: lc_ctrl_lc_nvm_rma_seed
        width: 1
        type: uni
        end_idx: -1
        act: req
        suffix: ""
        default: "'0"
      }
      {
        package: otp_ctrl_pkg
        struct: sram_otp_key_req
        domain: Main
        signame: otp_ctrl_sram_otp_key_req
        width: 5
        type: req_rsp
        end_idx: -1
        act: rsp
        suffix: req
        default: "'0"
      }
      {
        package: otp_ctrl_pkg
        struct: sram_otp_key_rsp
        domain: Main
        signame: otp_ctrl_sram_otp_key_rsp
        width: 5
        type: req_rsp
        end_idx: -1
        act: rsp
        suffix: rsp
        default: "'0"
      }
      {
        package: pwrmgr_pkg
        struct: pwr_ast_req
        domain: Aon
        signame: pwrmgr_pwr_ast_req
        width: 1
        type: req_rsp
        end_idx: -1
        act: req
        suffix: req
        default: ""
      }
      {
        package: pwrmgr_pkg
        struct: pwr_ast_rsp
        domain: Aon
        signame: pwrmgr_pwr_ast_rsp
        width: 1
        type: req_rsp
        end_idx: -1
        act: req
        suffix: rsp
        default: pwrmgr_pkg::PWR_AST_RSP_DEFAULT
      }
      {
        package: pwrmgr_pkg
        struct: pwr_rst_req
        domain: Aon
        signame: pwrmgr_pwr_rst_req
        width: 1
        type: req_rsp
        end_idx: -1
        act: req
        suffix: req
        default: ""
      }
      {
        package: pwrmgr_pkg
        struct: pwr_rst_rsp
        domain: Aon
        signame: pwrmgr_pwr_rst_rsp
        width: 1
        type: req_rsp
        end_idx: -1
        act: req
        suffix: rsp
        default: pwrmgr_pkg::PWR_RST_RSP_DEFAULT
      }
      {
        package: pwrmgr_pkg
        struct: pwr_clk_req
        domain: Aon
        signame: pwrmgr_pwr_clk_req
        width: 1
        type: req_rsp
        end_idx: -1
        act: req
        suffix: req
        default: ""
      }
      {
        package: pwrmgr_pkg
        struct: pwr_clk_rsp
        domain: Aon
        signame: pwrmgr_pwr_clk_rsp
        width: 1
        type: req_rsp
        end_idx: -1
        act: req
        suffix: rsp
        default: pwrmgr_pkg::PWR_CLK_RSP_DEFAULT
      }
      {
        package: ""
        struct: logic
        domain: Aon
        signame: pwrmgr_strap
        width: 1
        type: uni
        end_idx: -1
        act: req
        suffix: ""
        default: 1'b0
      }
      {
        package: ""
        struct: logic
        domain: Aon
        signame: pwrmgr_low_power
        width: 1
        type: uni
        end_idx: -1
        act: req
        suffix: ""
        default: 1'b0
      }
      {
        package: rom_ctrl_pkg
        struct: keymgr_data
        domain: Main
        signame: rom_ctrl_keymgr_data
        width: 1
        type: uni
        end_idx: -1
        act: req
        suffix: ""
        default: rom_ctrl_pkg::KEYMGR_DATA_DEFAULT
      }
      {
        package: lc_ctrl_pkg
        struct: lc_tx
        domain: Main
        signame: lc_ctrl_lc_nvm_rma_req
        width: 1
        type: uni
        end_idx: -1
        act: req
        suffix: ""
        default: lc_ctrl_pkg::Off
      }
      {
        package: lc_ctrl_pkg
        struct: lc_tx
        domain: Main
        signame: lc_ctrl_lc_nvm_rma_ack
        width: 2
        type: uni
        end_idx: -1
        act: rcv
        suffix: ""
        default: lc_ctrl_pkg::On
      }
      {
        package: edn_pkg
        struct: edn_req
        domain: Main
        signame: edn0_edn_req
        width:
        {
          name: NumEndPoints
          desc: Number of endpoints
          param_type: int unsigned
          unpacked_dimensions: null
          default: 8
          local: true
          expose: true
          name_top: Edn0NumEndPoints
        }
        type: req_rsp
        end_idx: -1
        act: rsp
        suffix: req
        default: "'0"
      }
      {
        package: edn_pkg
        struct: edn_rsp
        domain: Main
        signame: edn0_edn_rsp
        width:
        {
          name: NumEndPoints
          desc: Number of endpoints
          param_type: int unsigned
          unpacked_dimensions: null
          default: 8
          local: true
          expose: true
          name_top: Edn0NumEndPoints
        }
        type: req_rsp
        end_idx: -1
        act: rsp
        suffix: rsp
        default: ""
      }
      {
        package: edn_pkg
        struct: edn_req
        domain: Main
        signame: edn1_edn_req
        width:
        {
          name: NumEndPoints
          desc: Number of endpoints
          param_type: int unsigned
          unpacked_dimensions: null
          default: 8
          local: true
          expose: true
          name_top: Edn1NumEndPoints
        }
        type: req_rsp
        end_idx: -1
        act: rsp
        suffix: req
        default: "'0"
      }
      {
        package: edn_pkg
        struct: edn_rsp
        domain: Main
        signame: edn1_edn_rsp
        width:
        {
          name: NumEndPoints
          desc: Number of endpoints
          param_type: int unsigned
          unpacked_dimensions: null
          default: 8
          local: true
          expose: true
          name_top: Edn1NumEndPoints
        }
        type: req_rsp
        end_idx: -1
        act: rsp
        suffix: rsp
        default: ""
      }
      {
        package: otp_ctrl_pkg
        struct: otbn_otp_key_req
        domain: Main
        signame: otp_ctrl_otbn_otp_key_req
        width: 1
        type: req_rsp
        end_idx: -1
        act: rsp
        suffix: req
        default: "'0"
      }
      {
        package: otp_ctrl_pkg
        struct: otbn_otp_key_rsp
        domain: Main
        signame: otp_ctrl_otbn_otp_key_rsp
        width: 1
        type: req_rsp
        end_idx: -1
        act: rsp
        suffix: rsp
        default: ""
      }
      {
        package: keymgr_dpe_pkg
        struct: keymgr_dpe_creator_root_key
        domain: Main
        signame: otp_ctrl_keymgr_creator_root_key
        width: 1
        type: uni
        end_idx: -1
        act: req
        suffix: ""
        default: "'0"
      }
      {
        package: keymgr_dpe_pkg
        struct: keymgr_dpe_creator_seed
        domain: Main
        signame: rram_ctrl_keymgr_creator_seed
        width: 1
        type: uni
        end_idx: -1
        act: req
        suffix: ""
        default: "'0"
      }
      {
        package: keymgr_dpe_pkg
        struct: keymgr_dpe_owner_seed
        domain: Main
        signame: rram_ctrl_keymgr_owner_seed
        width: 1
        type: uni
        end_idx: -1
        act: req
        suffix: ""
        default: "'0"
      }
      {
        package: keymgr_dpe_pkg
        struct: hw_key_req
        domain: Main
        signame: keymgr_dpe_aes_key
        width: 1
        type: uni
        end_idx: -1
        act: req
        suffix: ""
        default: keymgr_dpe_pkg::HW_KEY_REQ_DEFAULT
      }
      {
        package: keymgr_dpe_pkg
        struct: hw_key_req
        domain: Main
        signame: keymgr_dpe_kmac_key
        width: 1
        type: uni
        end_idx: -1
        act: req
        suffix: ""
        default: keymgr_dpe_pkg::HW_KEY_REQ_DEFAULT
      }
      {
        package: keymgr_dpe_pkg
        struct: wide_hw_key_req
        domain: Main
        signame: keymgr_dpe_hmac_key
        width: 1
        type: uni
        end_idx: -1
        act: req
        suffix: ""
        default: keymgr_dpe_pkg::WIDE_HW_KEY_REQ_DEFAULT
      }
      {
        package: keymgr_dpe_pkg
        struct: wide_hw_key_req
        domain: Main
        signame: keymgr_dpe_otbn_key
        width: 1
        type: uni
        end_idx: -1
        act: req
        suffix: ""
        default: keymgr_dpe_pkg::WIDE_HW_KEY_REQ_DEFAULT
      }
      {
        package: kmac_pkg
        struct: app_req
        domain: Main
        signame: kmac_app_req
        width:
        {
          name: NumAppIntf
          desc: Number of application interfaces
          param_type: int
          unpacked_dimensions: null
          default: 4
          local: false
          expose: true
          name_top: KmacNumAppIntf
        }
        type: req_rsp
        end_idx: -1
        act: rsp
        suffix: req
        default: kmac_pkg::APP_REQ_DEFAULT
      }
      {
        package: kmac_pkg
        struct: app_rsp
        domain: Main
        signame: kmac_app_rsp
        width:
        {
          name: NumAppIntf
          desc: Number of application interfaces
          param_type: int
          unpacked_dimensions: null
          default: 4
          local: false
          expose: true
          name_top: KmacNumAppIntf
        }
        type: req_rsp
        end_idx: -1
        act: rsp
        suffix: rsp
        default: ""
      }
      {
        package: ""
        struct: logic
        domain: Main
        signame: kmac_en_masking
        width: 1
        type: uni
        end_idx: -1
        act: req
        suffix: ""
        default: 1'b0
      }
      {
        package: kmac_pkg
        struct: app_req
        domain: Main
        signame: otbn_keymgr_app_req
        width: 1
        type: req_rsp
        end_idx: -1
        act: rsp
        suffix: req
        default: kmac_pkg::APP_REQ_DEFAULT
      }
      {
        package: kmac_pkg
        struct: app_rsp
        domain: Main
        signame: otbn_keymgr_app_rsp
        width: 1
        type: req_rsp
        end_idx: -1
        act: rsp
        suffix: rsp
        default: ""
      }
      {
        package: prim_mubi_pkg
        struct: mubi4
        domain: Main
        signame: otbn_keymgr_sensitive_key
        width: 1
        type: uni
        end_idx: -1
        act: rcv
        suffix: ""
        default: prim_mubi_pkg::MuBi4False
      }
      {
        package: otp_ctrl_pkg
        struct: otp_lc_data
        domain: Main
        signame: otp_ctrl_otp_lc_data
        width: 1
        type: uni
        end_idx: -1
        act: req
        suffix: ""
        default: "'0"
      }
      {
        package: otp_ctrl_pkg
        struct: lc_otp_program_req
        domain: Main
        signame: lc_ctrl_lc_otp_program_req
        width: 1
        type: req_rsp
        end_idx: -1
        act: req
        suffix: req
        default: ""
      }
      {
        package: otp_ctrl_pkg
        struct: lc_otp_program_rsp
        domain: Main
        signame: lc_ctrl_lc_otp_program_rsp
        width: 1
        type: req_rsp
        end_idx: -1
        act: req
        suffix: rsp
        default: "'0"
      }
      {
        package: lc_ctrl_pkg
        struct: lc_keymgr_div
        domain: Main
        signame: lc_ctrl_lc_keymgr_div
        width: 1
        type: uni
        end_idx: -1
        act: req
        suffix: ""
        default: "'0"
      }
      {
        package: lc_ctrl_pkg
        struct: lc_tx
        domain: Main
        signame: lc_ctrl_lc_dft_en
        width: 1
        type: uni
        end_idx: -1
        act: req
        suffix: ""
        default: lc_ctrl_pkg::Off
      }
      {
        package: lc_ctrl_pkg
        struct: lc_tx
        domain: Main
        signame: lc_ctrl_lc_nvm_debug_en
        width: 1
        type: uni
        end_idx: -1
        act: req
        suffix: ""
        default: lc_ctrl_pkg::Off
      }
      {
        package: lc_ctrl_pkg
        struct: lc_tx
        domain: Main
        signame: lc_ctrl_lc_hw_debug_clr
        width: 1
        type: uni
        end_idx: -1
        act: req
        suffix: ""
        default: lc_ctrl_pkg::Off
      }
      {
        package: lc_ctrl_pkg
        struct: lc_tx
        domain: Main
        signame: lc_ctrl_lc_init_done
        width: 1
        type: uni
        end_idx: -1
        act: req
        suffix: ""
        default: lc_ctrl_pkg::Off
      }
      {
        package: lc_ctrl_pkg
        struct: lc_tx
        domain: Main
        signame: lc_ctrl_lc_hw_debug_en
        width: 1
        type: uni
        end_idx: -1
        act: req
        suffix: ""
        default: lc_ctrl_pkg::Off
      }
      {
        package: lc_ctrl_pkg
        struct: lc_tx
        domain: Main
        signame: lc_ctrl_lc_cpu_en
        width: 1
        type: uni
        end_idx: -1
        act: req
        suffix: ""
        default: lc_ctrl_pkg::Off
      }
      {
        package: lc_ctrl_pkg
        struct: lc_tx
        domain: Main
        signame: lc_ctrl_lc_keymgr_en
        width: 1
        type: uni
        end_idx: -1
        act: req
        suffix: ""
        default: lc_ctrl_pkg::Off
      }
      {
        package: lc_ctrl_pkg
        struct: lc_tx
        domain: Main
        signame: lc_ctrl_lc_escalate_en
        width: 1
        type: uni
        end_idx: -1
        act: req
        suffix: ""
        default: lc_ctrl_pkg::Off
      }
      {
        package: lc_ctrl_pkg
        struct: lc_tx
        domain: Main
        signame: lc_ctrl_lc_check_byp_en
        width: 1
        type: uni
        end_idx: -1
        act: req
        suffix: ""
        default: lc_ctrl_pkg::Off
      }
      {
        package: lc_ctrl_pkg
        struct: lc_tx
        domain: Main
        signame: lc_ctrl_lc_creator_seed_sw_rw_en
        width: 1
        type: uni
        end_idx: -1
        act: req
        suffix: ""
        default: lc_ctrl_pkg::Off
      }
      {
        package: lc_ctrl_pkg
        struct: lc_tx
        domain: Main
        signame: lc_ctrl_lc_owner_seed_sw_rw_en
        width: 1
        type: uni
        end_idx: -1
        act: req
        suffix: ""
        default: lc_ctrl_pkg::Off
      }
      {
        package: lc_ctrl_pkg
        struct: lc_tx
        domain: Main
        signame: lc_ctrl_lc_iso_part_sw_rd_en
        width: 1
        type: uni
        end_idx: -1
        act: req
        suffix: ""
        default: lc_ctrl_pkg::Off
      }
      {
        package: lc_ctrl_pkg
        struct: lc_tx
        domain: Main
        signame: lc_ctrl_lc_iso_part_sw_wr_en
        width: 1
        type: uni
        end_idx: -1
        act: req
        suffix: ""
        default: lc_ctrl_pkg::Off
      }
      {
        package: lc_ctrl_pkg
        struct: lc_tx
        domain: Main
        signame: lc_ctrl_lc_seed_hw_rd_en
        width: 1
        type: uni
        end_idx: -1
        act: req
        suffix: ""
        default: lc_ctrl_pkg::Off
      }
      {
        package: lc_ctrl_pkg
        struct: lc_tx
        domain: Main
        signame: lc_ctrl_lc_rma_state
        width: 1
        type: uni
        end_idx: -1
        act: req
        suffix: ""
        default: lc_ctrl_pkg::Off
      }
      {
        package: otp_ctrl_macro_pkg
        struct: otp_ctrl_macro_req
        domain: Main
        signame: otp_ctrl_otp_macro_req
        width: 1
        type: req_rsp
        end_idx: -1
        act: req
        suffix: req
        default: ""
      }
      {
        package: otp_ctrl_macro_pkg
        struct: otp_ctrl_macro_rsp
        domain: Main
        signame: otp_ctrl_otp_macro_rsp
        width: 1
        type: req_rsp
        end_idx: -1
        act: req
        suffix: rsp
        default: "'0"
      }
      {
        package: ""
        struct: logic
        domain: Main
        signame: rv_plic_msip
        width: 1
        type: uni
        end_idx: -1
        act: req
        suffix: ""
        default: 1'b0
      }
      {
        package: ""
        struct: logic
        domain: Main
        signame: rv_plic_irq
        width: 1
        type: uni
        end_idx: -1
        act: req
        suffix: ""
        default: 1'b0
      }
      {
        package: ""
        struct: logic [rv_dm_reg_pkg::NrHarts-1:0]
        domain: Main
        signame: rv_dm_debug_req
        width: 1
        type: uni
        end_idx: -1
        act: req
        suffix: ""
        default: "'0"
      }
      {
        package: tlul_pkg
        struct: tl_h2d
        domain: Main
        signame: rv_core_ibex_cored_tl_h_req
        width: 1
        type: req_rsp
        end_idx: -1
        act: req
        suffix: req
        default: ""
      }
      {
        package: tlul_pkg
        struct: tl_d2h
        domain: Main
        signame: rv_core_ibex_cored_tl_h_rsp
        width: 1
        type: req_rsp
        end_idx: -1
        act: req
        suffix: rsp
        default: tlul_pkg::TL_D2H_DEFAULT
      }
      {
        package: tlul_pkg
        struct: tl_h2d
        domain: Main
        signame: rv_core_ibex_corerevbm_tl_req
        width: 1
        type: req_rsp
        end_idx: -1
        act: req
        suffix: req
        default: ""
      }
      {
        package: tlul_pkg
        struct: tl_d2h
        domain: Main
        signame: rv_core_ibex_corerevbm_tl_rsp
        width: 1
        type: req_rsp
        end_idx: -1
        act: req
        suffix: rsp
        default: tlul_pkg::TL_D2H_DEFAULT
      }
      {
        package: ""
        struct: logic
        domain: Main
        signame: rv_core_ibex_cored_tag_h2d
        width: 1
        type: uni
        end_idx: -1
        act: req
        suffix: ""
        default: 1'b0
      }
      {
        package: spi_device_pkg
        struct: passthrough_req
        domain: Main
        signame: spi_device_passthrough_req
        width: 1
        type: req_rsp
        end_idx: -1
        act: req
        suffix: req
        default: ""
      }
      {
        package: spi_device_pkg
        struct: passthrough_rsp
        domain: Main
        signame: spi_device_passthrough_rsp
        width: 1
        type: req_rsp
        end_idx: -1
        act: req
        suffix: rsp
        default: spi_device_pkg::PASSTHROUGH_RSP_DEFAULT
      }
      {
        package: prim_mubi_pkg
        struct: mubi4
        domain: Aon
        signame: rstmgr_sw_rst_req
        width: 1
        type: uni
        end_idx: -1
        act: req
        suffix: ""
        default: prim_mubi_pkg::MUBI4_DEFAULT
      }
      {
        package: ""
        struct: logic
        domain: Aon
        signame: rstmgr_por_n
        width: 2
        type: uni
        end_idx: -1
        act: rcv
        suffix: ""
        default: "'0"
      }
      {
        package: rram_ctrl_pkg
        struct: rram_macro_req
        domain: Main
        signame: rram_ctrl_rram_macro_req
        width: 1
        type: req_rsp
        end_idx: -1
        act: req
        suffix: req
        default: ""
      }
      {
        package: rram_ctrl_pkg
        struct: rram_macro_rsp
        domain: Main
        signame: rram_ctrl_rram_macro_rsp
        width: 1
        type: req_rsp
        end_idx: -1
        act: req
        suffix: rsp
        default: rram_ctrl_pkg::RRAM_MACRO_RSP_DEFAULT
      }
      {
        package: tlul_pkg
        struct: tl_h2d
        domain: Main
        signame: cheriot_mem_sys_meta_sram_tl_req
        width: 1
        type: req_rsp
        end_idx: -1
        act: req
        suffix: req
        default: ""
      }
      {
        package: tlul_pkg
        struct: tl_d2h
        domain: Main
        signame: cheriot_mem_sys_meta_sram_tl_rsp
        width: 1
        type: req_rsp
        end_idx: -1
        act: req
        suffix: rsp
        default: tlul_pkg::TL_D2H_DEFAULT
      }
      {
        package: ""
        struct: logic
        domain: Main
        signame: cheriot_mem_sys_cored_tag_d2h
        width: 1
        type: uni
        end_idx: -1
        act: req
        suffix: ""
        default: 1'b0
      }
      {
        package: prim_mubi_pkg
        struct: mubi4
        domain: Main
        signame: rv_core_ibex_cheriot_ena
        width: 1
        type: uni
        end_idx: -1
        act: req
        suffix: ""
        default: prim_mubi_pkg::MuBi4False
      }
      {
        package: ""
        struct: logic
        domain: Aon
        signame: pwrmgr_wakeups
        width: 8
        type: uni
        end_idx: -1
        act: rcv
        suffix: ""
        default: "'0"
      }
      {
        package: ""
        struct: logic
        domain: Aon
        signame: pwrmgr_rstreqs
        width: 2
        type: uni
        end_idx: -1
        act: rcv
        suffix: ""
        default: "'0"
      }
      {
        package: ""
        struct: logic
        domain: Main
        signame: i3c1_rstdet_enable
        width: 1
        type: uni
        end_idx: -1
        act: req
        suffix: ""
        default: 1'b0
      }
      {
        package: i3c_pkg
        struct: i3c_rstdet_req
        domain: Main
        signame: i3c1_rstdet_req
        width: 1
        type: req_rsp
        end_idx: -1
        act: req
        suffix: req
        default: ""
      }
      {
        package: i3c_pkg
        struct: i3c_rstdet_rsp
        domain: Main
        signame: i3c1_rstdet_rsp
        width: 1
        type: req_rsp
        end_idx: -1
        act: req
        suffix: rsp
        default: i3c_pkg::I3C_RSTDET_RSP_DEFAULT
      }
      {
        package: tlul_pkg
        struct: tl_h2d
        domain: Main
        signame: main_tl_rv_core_ibex__corei_req
        width: 1
        type: req_rsp
        end_idx: -1
        act: rsp
        suffix: req
        default: tlul_pkg::TL_H2D_DEFAULT
      }
      {
        package: tlul_pkg
        struct: tl_d2h
        domain: Main
        signame: main_tl_rv_core_ibex__corei_rsp
        width: 1
        type: req_rsp
        end_idx: -1
        act: rsp
        suffix: rsp
        default: ""
      }
      {
        package: tlul_pkg
        struct: tl_h2d
        domain: Main
        signame: main_tl_cheriot_mem_sys__cored_req
        width: 1
        type: req_rsp
        end_idx: -1
        act: rsp
        suffix: req
        default: tlul_pkg::TL_H2D_DEFAULT
      }
      {
        package: tlul_pkg
        struct: tl_d2h
        domain: Main
        signame: main_tl_cheriot_mem_sys__cored_rsp
        width: 1
        type: req_rsp
        end_idx: -1
        act: rsp
        suffix: rsp
        default: ""
      }
      {
        package: tlul_pkg
        struct: tl_h2d
        domain: Main
        signame: main_tl_cheriot_mem_sys__tbre_req
        width: 1
        type: req_rsp
        end_idx: -1
        act: rsp
        suffix: req
        default: tlul_pkg::TL_H2D_DEFAULT
      }
      {
        package: tlul_pkg
        struct: tl_d2h
        domain: Main
        signame: main_tl_cheriot_mem_sys__tbre_rsp
        width: 1
        type: req_rsp
        end_idx: -1
        act: rsp
        suffix: rsp
        default: ""
      }
      {
        package: tlul_pkg
        struct: tl_h2d
        domain: Main
        signame: main_tl_rv_dm__sba_req
        width: 1
        type: req_rsp
        end_idx: -1
        act: rsp
        suffix: req
        default: tlul_pkg::TL_H2D_DEFAULT
      }
      {
        package: tlul_pkg
        struct: tl_d2h
        domain: Main
        signame: main_tl_rv_dm__sba_rsp
        width: 1
        type: req_rsp
        end_idx: -1
        act: rsp
        suffix: rsp
        default: ""
      }
      {
        package: tlul_pkg
        struct: tl_h2d
        domain: Main
        signame: rv_dm_regs_tl_d_req
        width: 1
        type: req_rsp
        end_idx: -1
        act: rsp
        suffix: req
        default: tlul_pkg::TL_H2D_DEFAULT
      }
      {
        package: tlul_pkg
        struct: tl_d2h
        domain: Main
        signame: rv_dm_regs_tl_d_rsp
        width: 1
        type: req_rsp
        end_idx: -1
        act: rsp
        suffix: rsp
        default: ""
      }
      {
        package: tlul_pkg
        struct: tl_h2d
        domain: Main
        signame: rv_dm_mem_tl_d_req
        width: 1
        type: req_rsp
        end_idx: -1
        act: rsp
        suffix: req
        default: tlul_pkg::TL_H2D_DEFAULT
      }
      {
        package: tlul_pkg
        struct: tl_d2h
        domain: Main
        signame: rv_dm_mem_tl_d_rsp
        width: 1
        type: req_rsp
        end_idx: -1
        act: rsp
        suffix: rsp
        default: ""
      }
      {
        package: tlul_pkg
        struct: tl_h2d
        domain: Main
        signame: rom_ctrl_rom_tl_req
        width: 1
        type: req_rsp
        end_idx: -1
        act: rsp
        suffix: req
        default: tlul_pkg::TL_H2D_DEFAULT
      }
      {
        package: tlul_pkg
        struct: tl_d2h
        domain: Main
        signame: rom_ctrl_rom_tl_rsp
        width: 1
        type: req_rsp
        end_idx: -1
        act: rsp
        suffix: rsp
        default: ""
      }
      {
        package: tlul_pkg
        struct: tl_h2d
        domain: Main
        signame: rom_ctrl_regs_tl_req
        width: 1
        type: req_rsp
        end_idx: -1
        act: rsp
        suffix: req
        default: tlul_pkg::TL_H2D_DEFAULT
      }
      {
        package: tlul_pkg
        struct: tl_d2h
        domain: Main
        signame: rom_ctrl_regs_tl_rsp
        width: 1
        type: req_rsp
        end_idx: -1
        act: rsp
        suffix: rsp
        default: ""
      }
      {
        package: tlul_pkg
        struct: tl_h2d
        domain: Main
        signame: main_tl_peri_req
        width: 1
        type: req_rsp
        end_idx: -1
        act: req
        suffix: req
        default: ""
      }
      {
        package: tlul_pkg
        struct: tl_d2h
        domain: Main
        signame: main_tl_peri_rsp
        width: 1
        type: req_rsp
        end_idx: -1
        act: req
        suffix: rsp
        default: tlul_pkg::TL_D2H_DEFAULT
      }
      {
        package: tlul_pkg
        struct: tl_h2d
        domain: Main
        signame: spi_host0_tl_req
        width: 1
        type: req_rsp
        end_idx: -1
        act: rsp
        suffix: req
        default: tlul_pkg::TL_H2D_DEFAULT
      }
      {
        package: tlul_pkg
        struct: tl_d2h
        domain: Main
        signame: spi_host0_tl_rsp
        width: 1
        type: req_rsp
        end_idx: -1
        act: rsp
        suffix: rsp
        default: ""
      }
      {
        package: tlul_pkg
        struct: tl_h2d
        domain: Main
        signame: spi_host1_tl_req
        width: 1
        type: req_rsp
        end_idx: -1
        act: rsp
        suffix: req
        default: tlul_pkg::TL_H2D_DEFAULT
      }
      {
        package: tlul_pkg
        struct: tl_d2h
        domain: Main
        signame: spi_host1_tl_rsp
        width: 1
        type: req_rsp
        end_idx: -1
        act: rsp
        suffix: rsp
        default: ""
      }
      {
        package: tlul_pkg
        struct: tl_h2d
        domain: Main
        signame: i3c0_tl_req
        width: 1
        type: req_rsp
        end_idx: -1
        act: rsp
        suffix: req
        default: tlul_pkg::TL_H2D_DEFAULT
      }
      {
        package: tlul_pkg
        struct: tl_d2h
        domain: Main
        signame: i3c0_tl_rsp
        width: 1
        type: req_rsp
        end_idx: -1
        act: rsp
        suffix: rsp
        default: ""
      }
      {
        package: tlul_pkg
        struct: tl_h2d
        domain: Main
        signame: i3c1_tl_req
        width: 1
        type: req_rsp
        end_idx: -1
        act: rsp
        suffix: req
        default: tlul_pkg::TL_H2D_DEFAULT
      }
      {
        package: tlul_pkg
        struct: tl_d2h
        domain: Main
        signame: i3c1_tl_rsp
        width: 1
        type: req_rsp
        end_idx: -1
        act: rsp
        suffix: rsp
        default: ""
      }
      {
        package: tlul_pkg
        struct: tl_h2d
        domain: Main
        signame: usbdev_tl_req
        width: 1
        type: req_rsp
        end_idx: -1
        act: rsp
        suffix: req
        default: tlul_pkg::TL_H2D_DEFAULT
      }
      {
        package: tlul_pkg
        struct: tl_d2h
        domain: Main
        signame: usbdev_tl_rsp
        width: 1
        type: req_rsp
        end_idx: -1
        act: rsp
        suffix: rsp
        default: ""
      }
      {
        package: tlul_pkg
        struct: tl_h2d
        domain: Main
        signame: rram_ctrl_core_tl_req
        width: 1
        type: req_rsp
        end_idx: -1
        act: rsp
        suffix: req
        default: tlul_pkg::TL_H2D_DEFAULT
      }
      {
        package: tlul_pkg
        struct: tl_d2h
        domain: Main
        signame: rram_ctrl_core_tl_rsp
        width: 1
        type: req_rsp
        end_idx: -1
        act: rsp
        suffix: rsp
        default: ""
      }
      {
        package: tlul_pkg
        struct: tl_h2d
        domain: Main
        signame: rram_macro_prim_tl_req
        width: 1
        type: req_rsp
        end_idx: -1
        act: rsp
        suffix: req
        default: tlul_pkg::TL_H2D_DEFAULT
      }
      {
        package: tlul_pkg
        struct: tl_d2h
        domain: Main
        signame: rram_macro_prim_tl_rsp
        width: 1
        type: req_rsp
        end_idx: -1
        act: rsp
        suffix: rsp
        default: ""
      }
      {
        package: tlul_pkg
        struct: tl_h2d
        domain: Main
        signame: rram_ctrl_host_tl_req
        width: 1
        type: req_rsp
        end_idx: -1
        act: rsp
        suffix: req
        default: tlul_pkg::TL_H2D_DEFAULT
      }
      {
        package: tlul_pkg
        struct: tl_d2h
        domain: Main
        signame: rram_ctrl_host_tl_rsp
        width: 1
        type: req_rsp
        end_idx: -1
        act: rsp
        suffix: rsp
        default: ""
      }
      {
        package: tlul_pkg
        struct: tl_h2d
        domain: Main
        signame: hmac_tl_req
        width: 1
        type: req_rsp
        end_idx: -1
        act: rsp
        suffix: req
        default: tlul_pkg::TL_H2D_DEFAULT
      }
      {
        package: tlul_pkg
        struct: tl_d2h
        domain: Main
        signame: hmac_tl_rsp
        width: 1
        type: req_rsp
        end_idx: -1
        act: rsp
        suffix: rsp
        default: ""
      }
      {
        package: tlul_pkg
        struct: tl_h2d
        domain: Main
        signame: kmac_tl_req
        width: 1
        type: req_rsp
        end_idx: -1
        act: rsp
        suffix: req
        default: tlul_pkg::TL_H2D_DEFAULT
      }
      {
        package: tlul_pkg
        struct: tl_d2h
        domain: Main
        signame: kmac_tl_rsp
        width: 1
        type: req_rsp
        end_idx: -1
        act: rsp
        suffix: rsp
        default: ""
      }
      {
        package: tlul_pkg
        struct: tl_h2d
        domain: Main
        signame: aes_tl_req
        width: 1
        type: req_rsp
        end_idx: -1
        act: rsp
        suffix: req
        default: tlul_pkg::TL_H2D_DEFAULT
      }
      {
        package: tlul_pkg
        struct: tl_d2h
        domain: Main
        signame: aes_tl_rsp
        width: 1
        type: req_rsp
        end_idx: -1
        act: rsp
        suffix: rsp
        default: ""
      }
      {
        package: tlul_pkg
        struct: tl_h2d
        domain: Main
        signame: entropy_src_tl_req
        width: 1
        type: req_rsp
        end_idx: -1
        act: rsp
        suffix: req
        default: tlul_pkg::TL_H2D_DEFAULT
      }
      {
        package: tlul_pkg
        struct: tl_d2h
        domain: Main
        signame: entropy_src_tl_rsp
        width: 1
        type: req_rsp
        end_idx: -1
        act: rsp
        suffix: rsp
        default: ""
      }
      {
        package: tlul_pkg
        struct: tl_h2d
        domain: Main
        signame: csrng_tl_req
        width: 1
        type: req_rsp
        end_idx: -1
        act: rsp
        suffix: req
        default: tlul_pkg::TL_H2D_DEFAULT
      }
      {
        package: tlul_pkg
        struct: tl_d2h
        domain: Main
        signame: csrng_tl_rsp
        width: 1
        type: req_rsp
        end_idx: -1
        act: rsp
        suffix: rsp
        default: ""
      }
      {
        package: tlul_pkg
        struct: tl_h2d
        domain: Main
        signame: edn0_tl_req
        width: 1
        type: req_rsp
        end_idx: -1
        act: rsp
        suffix: req
        default: tlul_pkg::TL_H2D_DEFAULT
      }
      {
        package: tlul_pkg
        struct: tl_d2h
        domain: Main
        signame: edn0_tl_rsp
        width: 1
        type: req_rsp
        end_idx: -1
        act: rsp
        suffix: rsp
        default: ""
      }
      {
        package: tlul_pkg
        struct: tl_h2d
        domain: Main
        signame: edn1_tl_req
        width: 1
        type: req_rsp
        end_idx: -1
        act: rsp
        suffix: req
        default: tlul_pkg::TL_H2D_DEFAULT
      }
      {
        package: tlul_pkg
        struct: tl_d2h
        domain: Main
        signame: edn1_tl_rsp
        width: 1
        type: req_rsp
        end_idx: -1
        act: rsp
        suffix: rsp
        default: ""
      }
      {
        package: tlul_pkg
        struct: tl_h2d
        domain: Main
        signame: rv_plic_tl_req
        width: 1
        type: req_rsp
        end_idx: -1
        act: rsp
        suffix: req
        default: tlul_pkg::TL_H2D_DEFAULT
      }
      {
        package: tlul_pkg
        struct: tl_d2h
        domain: Main
        signame: rv_plic_tl_rsp
        width: 1
        type: req_rsp
        end_idx: -1
        act: rsp
        suffix: rsp
        default: ""
      }
      {
        package: tlul_pkg
        struct: tl_h2d
        domain: Main
        signame: otbn_tl_req
        width: 1
        type: req_rsp
        end_idx: -1
        act: rsp
        suffix: req
        default: tlul_pkg::TL_H2D_DEFAULT
      }
      {
        package: tlul_pkg
        struct: tl_d2h
        domain: Main
        signame: otbn_tl_rsp
        width: 1
        type: req_rsp
        end_idx: -1
        act: rsp
        suffix: rsp
        default: ""
      }
      {
        package: tlul_pkg
        struct: tl_h2d
        domain: Main
        signame: keymgr_dpe_tl_req
        width: 1
        type: req_rsp
        end_idx: -1
        act: rsp
        suffix: req
        default: tlul_pkg::TL_H2D_DEFAULT
      }
      {
        package: tlul_pkg
        struct: tl_d2h
        domain: Main
        signame: keymgr_dpe_tl_rsp
        width: 1
        type: req_rsp
        end_idx: -1
        act: rsp
        suffix: rsp
        default: ""
      }
      {
        package: tlul_pkg
        struct: tl_h2d
        domain: Main
        signame: rv_core_ibex_cfg_tl_d_req
        width: 1
        type: req_rsp
        end_idx: -1
        act: rsp
        suffix: req
        default: tlul_pkg::TL_H2D_DEFAULT
      }
      {
        package: tlul_pkg
        struct: tl_d2h
        domain: Main
        signame: rv_core_ibex_cfg_tl_d_rsp
        width: 1
        type: req_rsp
        end_idx: -1
        act: rsp
        suffix: rsp
        default: ""
      }
      {
        package: tlul_pkg
        struct: tl_h2d
        domain: Main
        signame: sram_ctrl_main_regs_tl_req
        width: 1
        type: req_rsp
        end_idx: -1
        act: rsp
        suffix: req
        default: tlul_pkg::TL_H2D_DEFAULT
      }
      {
        package: tlul_pkg
        struct: tl_d2h
        domain: Main
        signame: sram_ctrl_main_regs_tl_rsp
        width: 1
        type: req_rsp
        end_idx: -1
        act: rsp
        suffix: rsp
        default: ""
      }
      {
        package: tlul_pkg
        struct: tl_h2d
        domain: Main
        signame: sram_ctrl_main_ram_tl_req
        width: 1
        type: req_rsp
        end_idx: -1
        act: rsp
        suffix: req
        default: tlul_pkg::TL_H2D_DEFAULT
      }
      {
        package: tlul_pkg
        struct: tl_d2h
        domain: Main
        signame: sram_ctrl_main_ram_tl_rsp
        width: 1
        type: req_rsp
        end_idx: -1
        act: rsp
        suffix: rsp
        default: ""
      }
      {
        package: tlul_pkg
        struct: tl_h2d
        domain: Main
        signame: sram_ctrl_sec_regs_tl_req
        width: 1
        type: req_rsp
        end_idx: -1
        act: rsp
        suffix: req
        default: tlul_pkg::TL_H2D_DEFAULT
      }
      {
        package: tlul_pkg
        struct: tl_d2h
        domain: Main
        signame: sram_ctrl_sec_regs_tl_rsp
        width: 1
        type: req_rsp
        end_idx: -1
        act: rsp
        suffix: rsp
        default: ""
      }
      {
        package: tlul_pkg
        struct: tl_h2d
        domain: Main
        signame: sram_ctrl_meta_regs_tl_req
        width: 1
        type: req_rsp
        end_idx: -1
        act: rsp
        suffix: req
        default: tlul_pkg::TL_H2D_DEFAULT
      }
      {
        package: tlul_pkg
        struct: tl_d2h
        domain: Main
        signame: sram_ctrl_meta_regs_tl_rsp
        width: 1
        type: req_rsp
        end_idx: -1
        act: rsp
        suffix: rsp
        default: ""
      }
      {
        package: tlul_pkg
        struct: tl_h2d
        domain: Main
        signame: sram_ctrl_sec_ram_tl_req
        width: 1
        type: req_rsp
        end_idx: -1
        act: rsp
        suffix: req
        default: tlul_pkg::TL_H2D_DEFAULT
      }
      {
        package: tlul_pkg
        struct: tl_d2h
        domain: Main
        signame: sram_ctrl_sec_ram_tl_rsp
        width: 1
        type: req_rsp
        end_idx: -1
        act: rsp
        suffix: rsp
        default: ""
      }
      {
        package: tlul_pkg
        struct: tl_h2d
        domain: Main
        signame: cheriot_mem_sys_regs_tl_d_req
        width: 1
        type: req_rsp
        end_idx: -1
        act: rsp
        suffix: req
        default: tlul_pkg::TL_H2D_DEFAULT
      }
      {
        package: tlul_pkg
        struct: tl_d2h
        domain: Main
        signame: cheriot_mem_sys_regs_tl_d_rsp
        width: 1
        type: req_rsp
        end_idx: -1
        act: rsp
        suffix: rsp
        default: ""
      }
      {
        package: tlul_pkg
        struct: tl_h2d
        domain: Main
        signame: cheriot_mem_sys_revbm_tl_d_req
        width: 1
        type: req_rsp
        end_idx: -1
        act: rsp
        suffix: req
        default: tlul_pkg::TL_H2D_DEFAULT
      }
      {
        package: tlul_pkg
        struct: tl_d2h
        domain: Main
        signame: cheriot_mem_sys_revbm_tl_d_rsp
        width: 1
        type: req_rsp
        end_idx: -1
        act: rsp
        suffix: rsp
        default: ""
      }
      {
        package: tlul_pkg
        struct: tl_h2d
        domain: Main
        signame: uart0_tl_req
        width: 1
        type: req_rsp
        end_idx: -1
        act: rsp
        suffix: req
        default: tlul_pkg::TL_H2D_DEFAULT
      }
      {
        package: tlul_pkg
        struct: tl_d2h
        domain: Main
        signame: uart0_tl_rsp
        width: 1
        type: req_rsp
        end_idx: -1
        act: rsp
        suffix: rsp
        default: ""
      }
      {
        package: tlul_pkg
        struct: tl_h2d
        domain: Main
        signame: uart1_tl_req
        width: 1
        type: req_rsp
        end_idx: -1
        act: rsp
        suffix: req
        default: tlul_pkg::TL_H2D_DEFAULT
      }
      {
        package: tlul_pkg
        struct: tl_d2h
        domain: Main
        signame: uart1_tl_rsp
        width: 1
        type: req_rsp
        end_idx: -1
        act: rsp
        suffix: rsp
        default: ""
      }
      {
        package: tlul_pkg
        struct: tl_h2d
        domain: Main
        signame: uart2_tl_req
        width: 1
        type: req_rsp
        end_idx: -1
        act: rsp
        suffix: req
        default: tlul_pkg::TL_H2D_DEFAULT
      }
      {
        package: tlul_pkg
        struct: tl_d2h
        domain: Main
        signame: uart2_tl_rsp
        width: 1
        type: req_rsp
        end_idx: -1
        act: rsp
        suffix: rsp
        default: ""
      }
      {
        package: tlul_pkg
        struct: tl_h2d
        domain: Main
        signame: uart3_tl_req
        width: 1
        type: req_rsp
        end_idx: -1
        act: rsp
        suffix: req
        default: tlul_pkg::TL_H2D_DEFAULT
      }
      {
        package: tlul_pkg
        struct: tl_d2h
        domain: Main
        signame: uart3_tl_rsp
        width: 1
        type: req_rsp
        end_idx: -1
        act: rsp
        suffix: rsp
        default: ""
      }
      {
        package: tlul_pkg
        struct: tl_h2d
        domain: Main
        signame: i2c0_tl_req
        width: 1
        type: req_rsp
        end_idx: -1
        act: rsp
        suffix: req
        default: tlul_pkg::TL_H2D_DEFAULT
      }
      {
        package: tlul_pkg
        struct: tl_d2h
        domain: Main
        signame: i2c0_tl_rsp
        width: 1
        type: req_rsp
        end_idx: -1
        act: rsp
        suffix: rsp
        default: ""
      }
      {
        package: tlul_pkg
        struct: tl_h2d
        domain: Main
        signame: i2c1_tl_req
        width: 1
        type: req_rsp
        end_idx: -1
        act: rsp
        suffix: req
        default: tlul_pkg::TL_H2D_DEFAULT
      }
      {
        package: tlul_pkg
        struct: tl_d2h
        domain: Main
        signame: i2c1_tl_rsp
        width: 1
        type: req_rsp
        end_idx: -1
        act: rsp
        suffix: rsp
        default: ""
      }
      {
        package: tlul_pkg
        struct: tl_h2d
        domain: Main
        signame: i2c2_tl_req
        width: 1
        type: req_rsp
        end_idx: -1
        act: rsp
        suffix: req
        default: tlul_pkg::TL_H2D_DEFAULT
      }
      {
        package: tlul_pkg
        struct: tl_d2h
        domain: Main
        signame: i2c2_tl_rsp
        width: 1
        type: req_rsp
        end_idx: -1
        act: rsp
        suffix: rsp
        default: ""
      }
      {
        package: tlul_pkg
        struct: tl_h2d
        domain: Main
        signame: gpio0_tl_req
        width: 1
        type: req_rsp
        end_idx: -1
        act: rsp
        suffix: req
        default: tlul_pkg::TL_H2D_DEFAULT
      }
      {
        package: tlul_pkg
        struct: tl_d2h
        domain: Main
        signame: gpio0_tl_rsp
        width: 1
        type: req_rsp
        end_idx: -1
        act: rsp
        suffix: rsp
        default: ""
      }
      {
        package: tlul_pkg
        struct: tl_h2d
        domain: Main
        signame: gpio1_tl_req
        width: 1
        type: req_rsp
        end_idx: -1
        act: rsp
        suffix: req
        default: tlul_pkg::TL_H2D_DEFAULT
      }
      {
        package: tlul_pkg
        struct: tl_d2h
        domain: Main
        signame: gpio1_tl_rsp
        width: 1
        type: req_rsp
        end_idx: -1
        act: rsp
        suffix: rsp
        default: ""
      }
      {
        package: tlul_pkg
        struct: tl_h2d
        domain: Main
        signame: spi_device_tl_req
        width: 1
        type: req_rsp
        end_idx: -1
        act: rsp
        suffix: req
        default: tlul_pkg::TL_H2D_DEFAULT
      }
      {
        package: tlul_pkg
        struct: tl_d2h
        domain: Main
        signame: spi_device_tl_rsp
        width: 1
        type: req_rsp
        end_idx: -1
        act: rsp
        suffix: rsp
        default: ""
      }
      {
        package: tlul_pkg
        struct: tl_h2d
        domain: Main
        signame: rv_timer_tl_req
        width: 1
        type: req_rsp
        end_idx: -1
        act: rsp
        suffix: req
        default: tlul_pkg::TL_H2D_DEFAULT
      }
      {
        package: tlul_pkg
        struct: tl_d2h
        domain: Main
        signame: rv_timer_tl_rsp
        width: 1
        type: req_rsp
        end_idx: -1
        act: rsp
        suffix: rsp
        default: ""
      }
      {
        package: tlul_pkg
        struct: tl_h2d
        domain: Main
        signame: otp_ctrl_core_tl_req
        width: 1
        type: req_rsp
        end_idx: -1
        act: rsp
        suffix: req
        default: tlul_pkg::TL_H2D_DEFAULT
      }
      {
        package: tlul_pkg
        struct: tl_d2h
        domain: Main
        signame: otp_ctrl_core_tl_rsp
        width: 1
        type: req_rsp
        end_idx: -1
        act: rsp
        suffix: rsp
        default: ""
      }
      {
        package: tlul_pkg
        struct: tl_h2d
        domain: Main
        signame: lc_ctrl_regs_tl_req
        width: 1
        type: req_rsp
        end_idx: -1
        act: rsp
        suffix: req
        default: tlul_pkg::TL_H2D_DEFAULT
      }
      {
        package: tlul_pkg
        struct: tl_d2h
        domain: Main
        signame: lc_ctrl_regs_tl_rsp
        width: 1
        type: req_rsp
        end_idx: -1
        act: rsp
        suffix: rsp
        default: ""
      }
      {
        package: tlul_pkg
        struct: tl_h2d
        domain: Main
        signame: alert_handler_tl_req
        width: 1
        type: req_rsp
        end_idx: -1
        act: rsp
        suffix: req
        default: tlul_pkg::TL_H2D_DEFAULT
      }
      {
        package: tlul_pkg
        struct: tl_d2h
        domain: Main
        signame: alert_handler_tl_rsp
        width: 1
        type: req_rsp
        end_idx: -1
        act: rsp
        suffix: rsp
        default: ""
      }
      {
        package: tlul_pkg
        struct: tl_h2d
        domain: Main
        signame: ast_tl_req
        width: 1
        type: req_rsp
        end_idx: -1
        act: rsp
        suffix: req
        default: tlul_pkg::TL_H2D_DEFAULT
      }
      {
        package: tlul_pkg
        struct: tl_d2h
        domain: Main
        signame: ast_tl_rsp
        width: 1
        type: req_rsp
        end_idx: -1
        act: rsp
        suffix: rsp
        default: ""
      }
      {
        package: clkmgr_pkg
        struct: clkmgr_out
        signame: clkmgr_clocks
        domain: Aon
        width: 1
        type: uni
        end_idx: -1
        default: ""
      }
      {
        package: ""
        struct: logic
        signame: ast_clk_src_aon
        domain: Aon
        width: 1
        type: uni
        end_idx: -1
        default: ""
      }
      {
        package: ast_pkg
        struct: clks_osc_byp
        signame: ast_clk_osc_byp
        domain: Main
        width: 1
        type: uni
        end_idx: -1
        default: ""
      }
      {
        package: ast_pkg
        struct: ast_mem_cfg_primary_req
        domain: Main
        signame: ast_mem_cfg_req
        width: 1
        type: req_rsp
        end_idx: -1
        default: ""
      }
      {
        package: ast_pkg
        struct: ast_mem_cfg_primary_rsp
        domain: Main
        signame: ast_mem_cfg_rsp
        width: 1
        type: req_rsp
        end_idx: -1
        default: ""
      }
      {
        package: prim_ram_1p_pkg
        struct: ram_1p_cfg_req
        domain: Main
        signame: otbn_ram_cfg_imem_req
        width: 1
        type: req_rsp
        end_idx: -1
        default: ""
      }
      {
        package: prim_ram_1p_pkg
        struct: ram_1p_cfg_rsp
        domain: Main
        signame: otbn_ram_cfg_imem_rsp
        width: 1
        type: req_rsp
        end_idx: -1
        default: ""
      }
      {
        package: prim_ram_1p_pkg
        struct: ram_1p_cfg_req
        domain: Main
        signame: otbn_ram_cfg_dmem_req
        width: 1
        type: req_rsp
        end_idx: -1
        default: ""
      }
      {
        package: prim_ram_1p_pkg
        struct: ram_1p_cfg_rsp
        domain: Main
        signame: otbn_ram_cfg_dmem_rsp
        width: 1
        type: req_rsp
        end_idx: -1
        default: ""
      }
      {
        package: prim_ram_1p_pkg
        struct: ram_1p_cfg_req
        domain: Main
        signame: i2c0_ram_cfg_req
        width: 1
        type: req_rsp
        end_idx: -1
        default: ""
      }
      {
        package: prim_ram_1p_pkg
        struct: ram_1p_cfg_rsp
        domain: Main
        signame: i2c0_ram_cfg_rsp
        width: 1
        type: req_rsp
        end_idx: -1
        default: ""
      }
      {
        package: prim_ram_1p_pkg
        struct: ram_1p_cfg_req
        domain: Main
        signame: i2c1_ram_cfg_req
        width: 1
        type: req_rsp
        end_idx: -1
        default: ""
      }
      {
        package: prim_ram_1p_pkg
        struct: ram_1p_cfg_rsp
        domain: Main
        signame: i2c1_ram_cfg_rsp
        width: 1
        type: req_rsp
        end_idx: -1
        default: ""
      }
      {
        package: prim_ram_1p_pkg
        struct: ram_1p_cfg_req
        domain: Main
        signame: i2c2_ram_cfg_req
        width: 1
        type: req_rsp
        end_idx: -1
        default: ""
      }
      {
        package: prim_ram_1p_pkg
        struct: ram_1p_cfg_rsp
        domain: Main
        signame: i2c2_ram_cfg_rsp
        width: 1
        type: req_rsp
        end_idx: -1
        default: ""
      }
      {
        package: prim_ram_1p_pkg
        struct: ram_1p_cfg_req
        domain: Main
        signame: i3c0_ram_cfg_req
        width: 1
        type: req_rsp
        end_idx: -1
        default: ""
      }
      {
        package: prim_ram_1p_pkg
        struct: ram_1p_cfg_rsp
        domain: Main
        signame: i3c0_ram_cfg_rsp
        width: 1
        type: req_rsp
        end_idx: -1
        default: ""
      }
      {
        package: prim_ram_1p_pkg
        struct: ram_1p_cfg_req
        domain: Main
        signame: i3c0_dat_cfg_req
        width: 1
        type: req_rsp
        end_idx: -1
        default: ""
      }
      {
        package: prim_ram_1p_pkg
        struct: ram_1p_cfg_rsp
        domain: Main
        signame: i3c0_dat_cfg_rsp
        width: 1
        type: req_rsp
        end_idx: -1
        default: ""
      }
      {
        package: prim_ram_1p_pkg
        struct: ram_1p_cfg_req
        domain: Main
        signame: i3c0_dct_cfg_req
        width: 1
        type: req_rsp
        end_idx: -1
        default: ""
      }
      {
        package: prim_ram_1p_pkg
        struct: ram_1p_cfg_rsp
        domain: Main
        signame: i3c0_dct_cfg_rsp
        width: 1
        type: req_rsp
        end_idx: -1
        default: ""
      }
      {
        package: prim_ram_1p_pkg
        struct: ram_1p_cfg_req
        domain: Main
        signame: i3c1_ram_cfg_req
        width: 1
        type: req_rsp
        end_idx: -1
        default: ""
      }
      {
        package: prim_ram_1p_pkg
        struct: ram_1p_cfg_rsp
        domain: Main
        signame: i3c1_ram_cfg_rsp
        width: 1
        type: req_rsp
        end_idx: -1
        default: ""
      }
      {
        package: prim_ram_1p_pkg
        struct: ram_1p_cfg_req
        domain: Main
        signame: i3c1_dat_cfg_req
        width: 1
        type: req_rsp
        end_idx: -1
        default: ""
      }
      {
        package: prim_ram_1p_pkg
        struct: ram_1p_cfg_rsp
        domain: Main
        signame: i3c1_dat_cfg_rsp
        width: 1
        type: req_rsp
        end_idx: -1
        default: ""
      }
      {
        package: prim_ram_1p_pkg
        struct: ram_1p_cfg_req
        domain: Main
        signame: i3c1_dct_cfg_req
        width: 1
        type: req_rsp
        end_idx: -1
        default: ""
      }
      {
        package: prim_ram_1p_pkg
        struct: ram_1p_cfg_rsp
        domain: Main
        signame: i3c1_dct_cfg_rsp
        width: 1
        type: req_rsp
        end_idx: -1
        default: ""
      }
      {
        package: prim_ram_1p_pkg
        struct: ram_1p_cfg_req
        domain: Main
        signame: usbdev_ram_cfg_req
        width: 1
        type: req_rsp
        end_idx: -1
        default: ""
      }
      {
        package: prim_ram_1p_pkg
        struct: ram_1p_cfg_rsp
        domain: Main
        signame: usbdev_ram_cfg_rsp
        width: 1
        type: req_rsp
        end_idx: -1
        default: ""
      }
      {
        package: prim_ram_1p_pkg
        struct: ram_1p_cfg_req
        domain: Main
        signame: rv_core_ibex_ram_cfg_icache_tag_req
        width:
        {
          name: ICacheNWays
          desc: Number of instruction cache ways
          param_type: int unsigned
          unpacked_dimensions: null
          default: 2
          local: false
          expose: true
          name_top: RvCoreIbexICacheNWays
        }
        type: req_rsp
        end_idx: -1
        default: ""
      }
      {
        package: prim_ram_1p_pkg
        struct: ram_1p_cfg_rsp
        domain: Main
        signame: rv_core_ibex_ram_cfg_icache_tag_rsp
        width:
        {
          name: ICacheNWays
          desc: Number of instruction cache ways
          param_type: int unsigned
          unpacked_dimensions: null
          default: 2
          local: false
          expose: true
          name_top: RvCoreIbexICacheNWays
        }
        type: req_rsp
        end_idx: -1
        default: ""
      }
      {
        package: prim_ram_1p_pkg
        struct: ram_1p_cfg_req
        domain: Main
        signame: rv_core_ibex_ram_cfg_icache_data_req
        width:
        {
          name: ICacheNWays
          desc: Number of instruction cache ways
          param_type: int unsigned
          unpacked_dimensions: null
          default: 2
          local: false
          expose: true
          name_top: RvCoreIbexICacheNWays
        }
        type: req_rsp
        end_idx: -1
        default: ""
      }
      {
        package: prim_ram_1p_pkg
        struct: ram_1p_cfg_rsp
        domain: Main
        signame: rv_core_ibex_ram_cfg_icache_data_rsp
        width:
        {
          name: ICacheNWays
          desc: Number of instruction cache ways
          param_type: int unsigned
          unpacked_dimensions: null
          default: 2
          local: false
          expose: true
          name_top: RvCoreIbexICacheNWays
        }
        type: req_rsp
        end_idx: -1
        default: ""
      }
      {
        package: prim_ram_1p_pkg
        struct: ram_1p_cfg_req
        domain: Main
        signame: sram_ctrl_main_ram_cfg_req
        width:
        {
          name: NumRamInst
          desc: Number of internal RAM instances. Must be the same as ceil(MemSizeRam / InstSize) .
          param_type: int
          unpacked_dimensions: null
          default: 1
          local: false
          expose: true
          name_top: SramCtrlMainNumRamInst
        }
        type: req_rsp
        end_idx: -1
        default: ""
      }
      {
        package: prim_ram_1p_pkg
        struct: ram_1p_cfg_rsp
        domain: Main
        signame: sram_ctrl_main_ram_cfg_rsp
        width:
        {
          name: NumRamInst
          desc: Number of internal RAM instances. Must be the same as ceil(MemSizeRam / InstSize) .
          param_type: int
          unpacked_dimensions: null
          default: 1
          local: false
          expose: true
          name_top: SramCtrlMainNumRamInst
        }
        type: req_rsp
        end_idx: -1
        default: ""
      }
      {
        package: prim_ram_1p_pkg
        struct: ram_1p_cfg_req
        domain: Main
        signame: sram_ctrl_sec_ram_cfg_req
        width:
        {
          name: NumRamInst
          desc: Number of internal RAM instances. Must be the same as ceil(MemSizeRam / InstSize) .
          param_type: int
          unpacked_dimensions: null
          default: 1
          local: false
          expose: true
          name_top: SramCtrlSecNumRamInst
        }
        type: req_rsp
        end_idx: -1
        default: ""
      }
      {
        package: prim_ram_1p_pkg
        struct: ram_1p_cfg_rsp
        domain: Main
        signame: sram_ctrl_sec_ram_cfg_rsp
        width:
        {
          name: NumRamInst
          desc: Number of internal RAM instances. Must be the same as ceil(MemSizeRam / InstSize) .
          param_type: int
          unpacked_dimensions: null
          default: 1
          local: false
          expose: true
          name_top: SramCtrlSecNumRamInst
        }
        type: req_rsp
        end_idx: -1
        default: ""
      }
      {
        package: prim_ram_1p_pkg
        struct: ram_1p_cfg_req
        domain: Main
        signame: sram_ctrl_meta_ram_cfg_req
        width:
        {
          name: NumRamInst
          desc: Number of internal RAM instances. Must be the same as ceil(MemSizeRam / InstSize) .
          param_type: int
          unpacked_dimensions: null
          default: 1
          local: false
          expose: true
          name_top: SramCtrlMetaNumRamInst
        }
        type: req_rsp
        end_idx: -1
        default: ""
      }
      {
        package: prim_ram_1p_pkg
        struct: ram_1p_cfg_rsp
        domain: Main
        signame: sram_ctrl_meta_ram_cfg_rsp
        width:
        {
          name: NumRamInst
          desc: Number of internal RAM instances. Must be the same as ceil(MemSizeRam / InstSize) .
          param_type: int
          unpacked_dimensions: null
          default: 1
          local: false
          expose: true
          name_top: SramCtrlMetaNumRamInst
        }
        type: req_rsp
        end_idx: -1
        default: ""
      }
      {
        package: prim_ram_1r1w_pkg
        struct: ram_1r1w_cfg_req
        domain: Main
        signame: spi_device_ram_cfg_sys2spi_req
        width: 1
        type: req_rsp
        end_idx: -1
        default: ""
      }
      {
        package: prim_ram_1r1w_pkg
        struct: ram_1r1w_cfg_rsp
        domain: Main
        signame: spi_device_ram_cfg_sys2spi_rsp
        width: 1
        type: req_rsp
        end_idx: -1
        default: ""
      }
      {
        package: prim_ram_1r1w_pkg
        struct: ram_1r1w_cfg_req
        domain: Main
        signame: spi_device_ram_cfg_spi2sys_req
        width: 1
        type: req_rsp
        end_idx: -1
        default: ""
      }
      {
        package: prim_ram_1r1w_pkg
        struct: ram_1r1w_cfg_rsp
        domain: Main
        signame: spi_device_ram_cfg_spi2sys_rsp
        width: 1
        type: req_rsp
        end_idx: -1
        default: ""
      }
      {
        package: prim_rom_pkg
        struct: rom_cfg_req
        domain: Main
        signame: rom_ctrl_rom_cfg_req
        width: 1
        type: req_rsp
        end_idx: -1
        default: ""
      }
      {
        package: prim_rom_pkg
        struct: rom_cfg_rsp
        domain: Main
        signame: rom_ctrl_rom_cfg_rsp
        width: 1
        type: req_rsp
        end_idx: -1
        default: ""
      }
      {
        package: ast_pkg
        struct: ast_mem_cfg_secondary_req
        domain: Aon
        signame: ast_mem_cfg_req
        width: 1
        type: req_rsp
        end_idx: -1
        default: ""
      }
      {
        package: ast_pkg
        struct: ast_mem_cfg_secondary_rsp
        domain: Aon
        signame: ast_mem_cfg_rsp
        width: 1
        type: req_rsp
        end_idx: -1
        default: ""
      }
      {
        package: prim_ram_1p_pkg
        struct: ram_1p_cfg_req
        domain: Aon
        signame: sram_ctrl_ret_ram_cfg_req
        width:
        {
          name: NumRamInst
          desc: Number of internal RAM instances. Must be the same as ceil(MemSizeRam / InstSize) .
          param_type: int
          unpacked_dimensions: null
          default: 1
          local: false
          expose: true
          name_top: SramCtrlRetNumRamInst
        }
        type: req_rsp
        end_idx: -1
        default: ""
      }
      {
        package: prim_ram_1p_pkg
        struct: ram_1p_cfg_rsp
        domain: Aon
        signame: sram_ctrl_ret_ram_cfg_rsp
        width:
        {
          name: NumRamInst
          desc: Number of internal RAM instances. Must be the same as ceil(MemSizeRam / InstSize) .
          param_type: int
          unpacked_dimensions: null
          default: 1
          local: false
          expose: true
          name_top: SramCtrlRetNumRamInst
        }
        type: req_rsp
        end_idx: -1
        default: ""
      }
      {
        package: clkmgr_pkg
        struct: clkmgr_cg_en
        signame: clkmgr_cg_en
        domain: Aon
        width: 1
        type: uni
        end_idx: -1
        default: ""
      }
      {
        package: rstmgr_pkg
        struct: rstmgr_out
        signame: rstmgr_resets
        domain: Aon
        width: 1
        type: uni
        end_idx: -1
        default: ""
      }
      {
        package: rstmgr_pkg
        struct: rstmgr_rst_en
        signame: rstmgr_rst_en
        domain: Aon
        width: 1
        type: uni
        end_idx: -1
        default: ""
      }
      {
        package: ""
        struct: logic
        signame: rv_core_ibex_irq_timer
        domain: Main
        width: 1
        type: uni
        end_idx: -1
        default: ""
      }
      {
        package: ""
        struct: logic
        signame: rv_core_ibex_hart_id
        domain: Main
        width: 32
        type: uni
        end_idx: -1
        default: ""
      }
      {
        package: ""
        struct: logic
        signame: rv_core_ibex_boot_addr
        domain: Main
        width: 32
        type: uni
        end_idx: -1
        default: ""
      }
      {
        package: jtag_pkg
        struct: jtag_req
        domain: Aon
        signame: pinmux_dft_jtag_req
        width: 1
        type: req_rsp
        end_idx: -1
        default: ""
      }
      {
        package: jtag_pkg
        struct: jtag_rsp
        domain: Aon
        signame: pinmux_dft_jtag_rsp
        width: 1
        type: req_rsp
        end_idx: -1
        default: ""
      }
      {
        package: otp_ctrl_part_pkg
        struct: otp_broadcast
        signame: otp_ctrl_otp_broadcast
        domain: Main
        width: 1
        type: uni
        end_idx: -1
        default: "'0"
      }
      {
        package: otp_ctrl_pkg
        struct: otp_device_id
        signame: lc_ctrl_otp_device_id
        domain: Main
        width: 1
        type: uni
        end_idx: -1
        default: "'0"
      }
      {
        package: otp_ctrl_pkg
        struct: otp_manuf_state
        signame: lc_ctrl_otp_manuf_state
        domain: Main
        width: 1
        type: uni
        end_idx: -1
        default: "'0"
      }
      {
        package: keymgr_dpe_pkg
        struct: keymgr_dpe_device_id
        signame: keymgr_dpe_device_id
        domain: Main
        width: 1
        type: uni
        end_idx: -1
        default: ""
      }
      {
        package: prim_mubi_pkg
        struct: mubi8
        signame: sram_ctrl_main_otp_en_sram_ifetch
        domain: Main
        width: 1
        type: uni
        end_idx: -1
        default: prim_mubi_pkg::MuBi8False
      }
      {
        package: prim_mubi_pkg
        struct: mubi8
        signame: sram_ctrl_sec_otp_en_sram_ifetch
        domain: Main
        width: 1
        type: uni
        end_idx: -1
        default: prim_mubi_pkg::MuBi8False
      }
      {
        package: prim_mubi_pkg
        struct: mubi8
        signame: rv_dm_otp_dis_rv_dm_late_debug
        domain: Main
        width: 1
        type: uni
        end_idx: -1
        default: prim_mubi_pkg::MuBi8False
      }
    ]
  }
}
